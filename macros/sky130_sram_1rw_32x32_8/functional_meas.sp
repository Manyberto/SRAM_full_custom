.meas tran vdout0_0ck40 FIND v(dout0_0) AT=50.05n

.meas tran vdout0_1ck40 FIND v(dout0_1) AT=50.05n

.meas tran vdout0_2ck40 FIND v(dout0_2) AT=50.05n

.meas tran vdout0_3ck40 FIND v(dout0_3) AT=50.05n

.meas tran vdout0_4ck40 FIND v(dout0_4) AT=50.05n

.meas tran vdout0_5ck40 FIND v(dout0_5) AT=50.05n

.meas tran vdout0_6ck40 FIND v(dout0_6) AT=50.05n

.meas tran vdout0_7ck40 FIND v(dout0_7) AT=50.05n

.meas tran vdout0_8ck40 FIND v(dout0_8) AT=50.05n

.meas tran vdout0_9ck40 FIND v(dout0_9) AT=50.05n

.meas tran vdout0_10ck40 FIND v(dout0_10) AT=50.05n

.meas tran vdout0_11ck40 FIND v(dout0_11) AT=50.05n

.meas tran vdout0_12ck40 FIND v(dout0_12) AT=50.05n

.meas tran vdout0_13ck40 FIND v(dout0_13) AT=50.05n

.meas tran vdout0_14ck40 FIND v(dout0_14) AT=50.05n

.meas tran vdout0_15ck40 FIND v(dout0_15) AT=50.05n

.meas tran vdout0_16ck40 FIND v(dout0_16) AT=50.05n

.meas tran vdout0_17ck40 FIND v(dout0_17) AT=50.05n

.meas tran vdout0_18ck40 FIND v(dout0_18) AT=50.05n

.meas tran vdout0_19ck40 FIND v(dout0_19) AT=50.05n

.meas tran vdout0_20ck40 FIND v(dout0_20) AT=50.05n

.meas tran vdout0_21ck40 FIND v(dout0_21) AT=50.05n

.meas tran vdout0_22ck40 FIND v(dout0_22) AT=50.05n

.meas tran vdout0_23ck40 FIND v(dout0_23) AT=50.05n

.meas tran vdout0_24ck40 FIND v(dout0_24) AT=50.05n

.meas tran vdout0_25ck40 FIND v(dout0_25) AT=50.05n

.meas tran vdout0_26ck40 FIND v(dout0_26) AT=50.05n

.meas tran vdout0_27ck40 FIND v(dout0_27) AT=50.05n

.meas tran vdout0_28ck40 FIND v(dout0_28) AT=50.05n

.meas tran vdout0_29ck40 FIND v(dout0_29) AT=50.05n

.meas tran vdout0_30ck40 FIND v(dout0_30) AT=50.05n

.meas tran vdout0_31ck40 FIND v(dout0_31) AT=50.05n

.meas tran vdout0_32ck40 FIND v(dout0_32) AT=50.05n

.meas tran vdout0_0ck70 FIND v(dout0_0) AT=80.05n

.meas tran vdout0_1ck70 FIND v(dout0_1) AT=80.05n

.meas tran vdout0_2ck70 FIND v(dout0_2) AT=80.05n

.meas tran vdout0_3ck70 FIND v(dout0_3) AT=80.05n

.meas tran vdout0_4ck70 FIND v(dout0_4) AT=80.05n

.meas tran vdout0_5ck70 FIND v(dout0_5) AT=80.05n

.meas tran vdout0_6ck70 FIND v(dout0_6) AT=80.05n

.meas tran vdout0_7ck70 FIND v(dout0_7) AT=80.05n

.meas tran vdout0_8ck70 FIND v(dout0_8) AT=80.05n

.meas tran vdout0_9ck70 FIND v(dout0_9) AT=80.05n

.meas tran vdout0_10ck70 FIND v(dout0_10) AT=80.05n

.meas tran vdout0_11ck70 FIND v(dout0_11) AT=80.05n

.meas tran vdout0_12ck70 FIND v(dout0_12) AT=80.05n

.meas tran vdout0_13ck70 FIND v(dout0_13) AT=80.05n

.meas tran vdout0_14ck70 FIND v(dout0_14) AT=80.05n

.meas tran vdout0_15ck70 FIND v(dout0_15) AT=80.05n

.meas tran vdout0_16ck70 FIND v(dout0_16) AT=80.05n

.meas tran vdout0_17ck70 FIND v(dout0_17) AT=80.05n

.meas tran vdout0_18ck70 FIND v(dout0_18) AT=80.05n

.meas tran vdout0_19ck70 FIND v(dout0_19) AT=80.05n

.meas tran vdout0_20ck70 FIND v(dout0_20) AT=80.05n

.meas tran vdout0_21ck70 FIND v(dout0_21) AT=80.05n

.meas tran vdout0_22ck70 FIND v(dout0_22) AT=80.05n

.meas tran vdout0_23ck70 FIND v(dout0_23) AT=80.05n

.meas tran vdout0_24ck70 FIND v(dout0_24) AT=80.05n

.meas tran vdout0_25ck70 FIND v(dout0_25) AT=80.05n

.meas tran vdout0_26ck70 FIND v(dout0_26) AT=80.05n

.meas tran vdout0_27ck70 FIND v(dout0_27) AT=80.05n

.meas tran vdout0_28ck70 FIND v(dout0_28) AT=80.05n

.meas tran vdout0_29ck70 FIND v(dout0_29) AT=80.05n

.meas tran vdout0_30ck70 FIND v(dout0_30) AT=80.05n

.meas tran vdout0_31ck70 FIND v(dout0_31) AT=80.05n

.meas tran vdout0_32ck70 FIND v(dout0_32) AT=80.05n

.meas tran vdout0_0ck90 FIND v(dout0_0) AT=100.05n

.meas tran vdout0_1ck90 FIND v(dout0_1) AT=100.05n

.meas tran vdout0_2ck90 FIND v(dout0_2) AT=100.05n

.meas tran vdout0_3ck90 FIND v(dout0_3) AT=100.05n

.meas tran vdout0_4ck90 FIND v(dout0_4) AT=100.05n

.meas tran vdout0_5ck90 FIND v(dout0_5) AT=100.05n

.meas tran vdout0_6ck90 FIND v(dout0_6) AT=100.05n

.meas tran vdout0_7ck90 FIND v(dout0_7) AT=100.05n

.meas tran vdout0_8ck90 FIND v(dout0_8) AT=100.05n

.meas tran vdout0_9ck90 FIND v(dout0_9) AT=100.05n

.meas tran vdout0_10ck90 FIND v(dout0_10) AT=100.05n

.meas tran vdout0_11ck90 FIND v(dout0_11) AT=100.05n

.meas tran vdout0_12ck90 FIND v(dout0_12) AT=100.05n

.meas tran vdout0_13ck90 FIND v(dout0_13) AT=100.05n

.meas tran vdout0_14ck90 FIND v(dout0_14) AT=100.05n

.meas tran vdout0_15ck90 FIND v(dout0_15) AT=100.05n

.meas tran vdout0_16ck90 FIND v(dout0_16) AT=100.05n

.meas tran vdout0_17ck90 FIND v(dout0_17) AT=100.05n

.meas tran vdout0_18ck90 FIND v(dout0_18) AT=100.05n

.meas tran vdout0_19ck90 FIND v(dout0_19) AT=100.05n

.meas tran vdout0_20ck90 FIND v(dout0_20) AT=100.05n

.meas tran vdout0_21ck90 FIND v(dout0_21) AT=100.05n

.meas tran vdout0_22ck90 FIND v(dout0_22) AT=100.05n

.meas tran vdout0_23ck90 FIND v(dout0_23) AT=100.05n

.meas tran vdout0_24ck90 FIND v(dout0_24) AT=100.05n

.meas tran vdout0_25ck90 FIND v(dout0_25) AT=100.05n

.meas tran vdout0_26ck90 FIND v(dout0_26) AT=100.05n

.meas tran vdout0_27ck90 FIND v(dout0_27) AT=100.05n

.meas tran vdout0_28ck90 FIND v(dout0_28) AT=100.05n

.meas tran vdout0_29ck90 FIND v(dout0_29) AT=100.05n

.meas tran vdout0_30ck90 FIND v(dout0_30) AT=100.05n

.meas tran vdout0_31ck90 FIND v(dout0_31) AT=100.05n

.meas tran vdout0_32ck90 FIND v(dout0_32) AT=100.05n

.meas tran vdout0_0ck100 FIND v(dout0_0) AT=110.05n

.meas tran vdout0_1ck100 FIND v(dout0_1) AT=110.05n

.meas tran vdout0_2ck100 FIND v(dout0_2) AT=110.05n

.meas tran vdout0_3ck100 FIND v(dout0_3) AT=110.05n

.meas tran vdout0_4ck100 FIND v(dout0_4) AT=110.05n

.meas tran vdout0_5ck100 FIND v(dout0_5) AT=110.05n

.meas tran vdout0_6ck100 FIND v(dout0_6) AT=110.05n

.meas tran vdout0_7ck100 FIND v(dout0_7) AT=110.05n

.meas tran vdout0_8ck100 FIND v(dout0_8) AT=110.05n

.meas tran vdout0_9ck100 FIND v(dout0_9) AT=110.05n

.meas tran vdout0_10ck100 FIND v(dout0_10) AT=110.05n

.meas tran vdout0_11ck100 FIND v(dout0_11) AT=110.05n

.meas tran vdout0_12ck100 FIND v(dout0_12) AT=110.05n

.meas tran vdout0_13ck100 FIND v(dout0_13) AT=110.05n

.meas tran vdout0_14ck100 FIND v(dout0_14) AT=110.05n

.meas tran vdout0_15ck100 FIND v(dout0_15) AT=110.05n

.meas tran vdout0_16ck100 FIND v(dout0_16) AT=110.05n

.meas tran vdout0_17ck100 FIND v(dout0_17) AT=110.05n

.meas tran vdout0_18ck100 FIND v(dout0_18) AT=110.05n

.meas tran vdout0_19ck100 FIND v(dout0_19) AT=110.05n

.meas tran vdout0_20ck100 FIND v(dout0_20) AT=110.05n

.meas tran vdout0_21ck100 FIND v(dout0_21) AT=110.05n

.meas tran vdout0_22ck100 FIND v(dout0_22) AT=110.05n

.meas tran vdout0_23ck100 FIND v(dout0_23) AT=110.05n

.meas tran vdout0_24ck100 FIND v(dout0_24) AT=110.05n

.meas tran vdout0_25ck100 FIND v(dout0_25) AT=110.05n

.meas tran vdout0_26ck100 FIND v(dout0_26) AT=110.05n

.meas tran vdout0_27ck100 FIND v(dout0_27) AT=110.05n

.meas tran vdout0_28ck100 FIND v(dout0_28) AT=110.05n

.meas tran vdout0_29ck100 FIND v(dout0_29) AT=110.05n

.meas tran vdout0_30ck100 FIND v(dout0_30) AT=110.05n

.meas tran vdout0_31ck100 FIND v(dout0_31) AT=110.05n

.meas tran vdout0_32ck100 FIND v(dout0_32) AT=110.05n

.meas tran vdout0_0ck120 FIND v(dout0_0) AT=130.05n

.meas tran vdout0_1ck120 FIND v(dout0_1) AT=130.05n

.meas tran vdout0_2ck120 FIND v(dout0_2) AT=130.05n

.meas tran vdout0_3ck120 FIND v(dout0_3) AT=130.05n

.meas tran vdout0_4ck120 FIND v(dout0_4) AT=130.05n

.meas tran vdout0_5ck120 FIND v(dout0_5) AT=130.05n

.meas tran vdout0_6ck120 FIND v(dout0_6) AT=130.05n

.meas tran vdout0_7ck120 FIND v(dout0_7) AT=130.05n

.meas tran vdout0_8ck120 FIND v(dout0_8) AT=130.05n

.meas tran vdout0_9ck120 FIND v(dout0_9) AT=130.05n

.meas tran vdout0_10ck120 FIND v(dout0_10) AT=130.05n

.meas tran vdout0_11ck120 FIND v(dout0_11) AT=130.05n

.meas tran vdout0_12ck120 FIND v(dout0_12) AT=130.05n

.meas tran vdout0_13ck120 FIND v(dout0_13) AT=130.05n

.meas tran vdout0_14ck120 FIND v(dout0_14) AT=130.05n

.meas tran vdout0_15ck120 FIND v(dout0_15) AT=130.05n

.meas tran vdout0_16ck120 FIND v(dout0_16) AT=130.05n

.meas tran vdout0_17ck120 FIND v(dout0_17) AT=130.05n

.meas tran vdout0_18ck120 FIND v(dout0_18) AT=130.05n

.meas tran vdout0_19ck120 FIND v(dout0_19) AT=130.05n

.meas tran vdout0_20ck120 FIND v(dout0_20) AT=130.05n

.meas tran vdout0_21ck120 FIND v(dout0_21) AT=130.05n

.meas tran vdout0_22ck120 FIND v(dout0_22) AT=130.05n

.meas tran vdout0_23ck120 FIND v(dout0_23) AT=130.05n

.meas tran vdout0_24ck120 FIND v(dout0_24) AT=130.05n

.meas tran vdout0_25ck120 FIND v(dout0_25) AT=130.05n

.meas tran vdout0_26ck120 FIND v(dout0_26) AT=130.05n

.meas tran vdout0_27ck120 FIND v(dout0_27) AT=130.05n

.meas tran vdout0_28ck120 FIND v(dout0_28) AT=130.05n

.meas tran vdout0_29ck120 FIND v(dout0_29) AT=130.05n

.meas tran vdout0_30ck120 FIND v(dout0_30) AT=130.05n

.meas tran vdout0_31ck120 FIND v(dout0_31) AT=130.05n

.meas tran vdout0_32ck120 FIND v(dout0_32) AT=130.05n

.meas tran vdout0_0ck130 FIND v(dout0_0) AT=140.05n

.meas tran vdout0_1ck130 FIND v(dout0_1) AT=140.05n

.meas tran vdout0_2ck130 FIND v(dout0_2) AT=140.05n

.meas tran vdout0_3ck130 FIND v(dout0_3) AT=140.05n

.meas tran vdout0_4ck130 FIND v(dout0_4) AT=140.05n

.meas tran vdout0_5ck130 FIND v(dout0_5) AT=140.05n

.meas tran vdout0_6ck130 FIND v(dout0_6) AT=140.05n

.meas tran vdout0_7ck130 FIND v(dout0_7) AT=140.05n

.meas tran vdout0_8ck130 FIND v(dout0_8) AT=140.05n

.meas tran vdout0_9ck130 FIND v(dout0_9) AT=140.05n

.meas tran vdout0_10ck130 FIND v(dout0_10) AT=140.05n

.meas tran vdout0_11ck130 FIND v(dout0_11) AT=140.05n

.meas tran vdout0_12ck130 FIND v(dout0_12) AT=140.05n

.meas tran vdout0_13ck130 FIND v(dout0_13) AT=140.05n

.meas tran vdout0_14ck130 FIND v(dout0_14) AT=140.05n

.meas tran vdout0_15ck130 FIND v(dout0_15) AT=140.05n

.meas tran vdout0_16ck130 FIND v(dout0_16) AT=140.05n

.meas tran vdout0_17ck130 FIND v(dout0_17) AT=140.05n

.meas tran vdout0_18ck130 FIND v(dout0_18) AT=140.05n

.meas tran vdout0_19ck130 FIND v(dout0_19) AT=140.05n

.meas tran vdout0_20ck130 FIND v(dout0_20) AT=140.05n

.meas tran vdout0_21ck130 FIND v(dout0_21) AT=140.05n

.meas tran vdout0_22ck130 FIND v(dout0_22) AT=140.05n

.meas tran vdout0_23ck130 FIND v(dout0_23) AT=140.05n

.meas tran vdout0_24ck130 FIND v(dout0_24) AT=140.05n

.meas tran vdout0_25ck130 FIND v(dout0_25) AT=140.05n

.meas tran vdout0_26ck130 FIND v(dout0_26) AT=140.05n

.meas tran vdout0_27ck130 FIND v(dout0_27) AT=140.05n

.meas tran vdout0_28ck130 FIND v(dout0_28) AT=140.05n

.meas tran vdout0_29ck130 FIND v(dout0_29) AT=140.05n

.meas tran vdout0_30ck130 FIND v(dout0_30) AT=140.05n

.meas tran vdout0_31ck130 FIND v(dout0_31) AT=140.05n

.meas tran vdout0_32ck130 FIND v(dout0_32) AT=140.05n

.meas tran vdout0_0ck140 FIND v(dout0_0) AT=150.05n

.meas tran vdout0_1ck140 FIND v(dout0_1) AT=150.05n

.meas tran vdout0_2ck140 FIND v(dout0_2) AT=150.05n

.meas tran vdout0_3ck140 FIND v(dout0_3) AT=150.05n

.meas tran vdout0_4ck140 FIND v(dout0_4) AT=150.05n

.meas tran vdout0_5ck140 FIND v(dout0_5) AT=150.05n

.meas tran vdout0_6ck140 FIND v(dout0_6) AT=150.05n

.meas tran vdout0_7ck140 FIND v(dout0_7) AT=150.05n

.meas tran vdout0_8ck140 FIND v(dout0_8) AT=150.05n

.meas tran vdout0_9ck140 FIND v(dout0_9) AT=150.05n

.meas tran vdout0_10ck140 FIND v(dout0_10) AT=150.05n

.meas tran vdout0_11ck140 FIND v(dout0_11) AT=150.05n

.meas tran vdout0_12ck140 FIND v(dout0_12) AT=150.05n

.meas tran vdout0_13ck140 FIND v(dout0_13) AT=150.05n

.meas tran vdout0_14ck140 FIND v(dout0_14) AT=150.05n

.meas tran vdout0_15ck140 FIND v(dout0_15) AT=150.05n

.meas tran vdout0_16ck140 FIND v(dout0_16) AT=150.05n

.meas tran vdout0_17ck140 FIND v(dout0_17) AT=150.05n

.meas tran vdout0_18ck140 FIND v(dout0_18) AT=150.05n

.meas tran vdout0_19ck140 FIND v(dout0_19) AT=150.05n

.meas tran vdout0_20ck140 FIND v(dout0_20) AT=150.05n

.meas tran vdout0_21ck140 FIND v(dout0_21) AT=150.05n

.meas tran vdout0_22ck140 FIND v(dout0_22) AT=150.05n

.meas tran vdout0_23ck140 FIND v(dout0_23) AT=150.05n

.meas tran vdout0_24ck140 FIND v(dout0_24) AT=150.05n

.meas tran vdout0_25ck140 FIND v(dout0_25) AT=150.05n

.meas tran vdout0_26ck140 FIND v(dout0_26) AT=150.05n

.meas tran vdout0_27ck140 FIND v(dout0_27) AT=150.05n

.meas tran vdout0_28ck140 FIND v(dout0_28) AT=150.05n

.meas tran vdout0_29ck140 FIND v(dout0_29) AT=150.05n

.meas tran vdout0_30ck140 FIND v(dout0_30) AT=150.05n

.meas tran vdout0_31ck140 FIND v(dout0_31) AT=150.05n

.meas tran vdout0_32ck140 FIND v(dout0_32) AT=150.05n

.meas tran vdout0_0ck150 FIND v(dout0_0) AT=160.05n

.meas tran vdout0_1ck150 FIND v(dout0_1) AT=160.05n

.meas tran vdout0_2ck150 FIND v(dout0_2) AT=160.05n

.meas tran vdout0_3ck150 FIND v(dout0_3) AT=160.05n

.meas tran vdout0_4ck150 FIND v(dout0_4) AT=160.05n

.meas tran vdout0_5ck150 FIND v(dout0_5) AT=160.05n

.meas tran vdout0_6ck150 FIND v(dout0_6) AT=160.05n

.meas tran vdout0_7ck150 FIND v(dout0_7) AT=160.05n

.meas tran vdout0_8ck150 FIND v(dout0_8) AT=160.05n

.meas tran vdout0_9ck150 FIND v(dout0_9) AT=160.05n

.meas tran vdout0_10ck150 FIND v(dout0_10) AT=160.05n

.meas tran vdout0_11ck150 FIND v(dout0_11) AT=160.05n

.meas tran vdout0_12ck150 FIND v(dout0_12) AT=160.05n

.meas tran vdout0_13ck150 FIND v(dout0_13) AT=160.05n

.meas tran vdout0_14ck150 FIND v(dout0_14) AT=160.05n

.meas tran vdout0_15ck150 FIND v(dout0_15) AT=160.05n

.meas tran vdout0_16ck150 FIND v(dout0_16) AT=160.05n

.meas tran vdout0_17ck150 FIND v(dout0_17) AT=160.05n

.meas tran vdout0_18ck150 FIND v(dout0_18) AT=160.05n

.meas tran vdout0_19ck150 FIND v(dout0_19) AT=160.05n

.meas tran vdout0_20ck150 FIND v(dout0_20) AT=160.05n

.meas tran vdout0_21ck150 FIND v(dout0_21) AT=160.05n

.meas tran vdout0_22ck150 FIND v(dout0_22) AT=160.05n

.meas tran vdout0_23ck150 FIND v(dout0_23) AT=160.05n

.meas tran vdout0_24ck150 FIND v(dout0_24) AT=160.05n

.meas tran vdout0_25ck150 FIND v(dout0_25) AT=160.05n

.meas tran vdout0_26ck150 FIND v(dout0_26) AT=160.05n

.meas tran vdout0_27ck150 FIND v(dout0_27) AT=160.05n

.meas tran vdout0_28ck150 FIND v(dout0_28) AT=160.05n

.meas tran vdout0_29ck150 FIND v(dout0_29) AT=160.05n

.meas tran vdout0_30ck150 FIND v(dout0_30) AT=160.05n

.meas tran vdout0_31ck150 FIND v(dout0_31) AT=160.05n

.meas tran vdout0_32ck150 FIND v(dout0_32) AT=160.05n

.meas tran vdout0_0ck170 FIND v(dout0_0) AT=180.05n

.meas tran vdout0_1ck170 FIND v(dout0_1) AT=180.05n

.meas tran vdout0_2ck170 FIND v(dout0_2) AT=180.05n

.meas tran vdout0_3ck170 FIND v(dout0_3) AT=180.05n

.meas tran vdout0_4ck170 FIND v(dout0_4) AT=180.05n

.meas tran vdout0_5ck170 FIND v(dout0_5) AT=180.05n

.meas tran vdout0_6ck170 FIND v(dout0_6) AT=180.05n

.meas tran vdout0_7ck170 FIND v(dout0_7) AT=180.05n

.meas tran vdout0_8ck170 FIND v(dout0_8) AT=180.05n

.meas tran vdout0_9ck170 FIND v(dout0_9) AT=180.05n

.meas tran vdout0_10ck170 FIND v(dout0_10) AT=180.05n

.meas tran vdout0_11ck170 FIND v(dout0_11) AT=180.05n

.meas tran vdout0_12ck170 FIND v(dout0_12) AT=180.05n

.meas tran vdout0_13ck170 FIND v(dout0_13) AT=180.05n

.meas tran vdout0_14ck170 FIND v(dout0_14) AT=180.05n

.meas tran vdout0_15ck170 FIND v(dout0_15) AT=180.05n

.meas tran vdout0_16ck170 FIND v(dout0_16) AT=180.05n

.meas tran vdout0_17ck170 FIND v(dout0_17) AT=180.05n

.meas tran vdout0_18ck170 FIND v(dout0_18) AT=180.05n

.meas tran vdout0_19ck170 FIND v(dout0_19) AT=180.05n

.meas tran vdout0_20ck170 FIND v(dout0_20) AT=180.05n

.meas tran vdout0_21ck170 FIND v(dout0_21) AT=180.05n

.meas tran vdout0_22ck170 FIND v(dout0_22) AT=180.05n

.meas tran vdout0_23ck170 FIND v(dout0_23) AT=180.05n

.meas tran vdout0_24ck170 FIND v(dout0_24) AT=180.05n

.meas tran vdout0_25ck170 FIND v(dout0_25) AT=180.05n

.meas tran vdout0_26ck170 FIND v(dout0_26) AT=180.05n

.meas tran vdout0_27ck170 FIND v(dout0_27) AT=180.05n

.meas tran vdout0_28ck170 FIND v(dout0_28) AT=180.05n

.meas tran vdout0_29ck170 FIND v(dout0_29) AT=180.05n

.meas tran vdout0_30ck170 FIND v(dout0_30) AT=180.05n

.meas tran vdout0_31ck170 FIND v(dout0_31) AT=180.05n

.meas tran vdout0_32ck170 FIND v(dout0_32) AT=180.05n

.meas tran vdout0_0ck190 FIND v(dout0_0) AT=200.05n

.meas tran vdout0_1ck190 FIND v(dout0_1) AT=200.05n

.meas tran vdout0_2ck190 FIND v(dout0_2) AT=200.05n

.meas tran vdout0_3ck190 FIND v(dout0_3) AT=200.05n

.meas tran vdout0_4ck190 FIND v(dout0_4) AT=200.05n

.meas tran vdout0_5ck190 FIND v(dout0_5) AT=200.05n

.meas tran vdout0_6ck190 FIND v(dout0_6) AT=200.05n

.meas tran vdout0_7ck190 FIND v(dout0_7) AT=200.05n

.meas tran vdout0_8ck190 FIND v(dout0_8) AT=200.05n

.meas tran vdout0_9ck190 FIND v(dout0_9) AT=200.05n

.meas tran vdout0_10ck190 FIND v(dout0_10) AT=200.05n

.meas tran vdout0_11ck190 FIND v(dout0_11) AT=200.05n

.meas tran vdout0_12ck190 FIND v(dout0_12) AT=200.05n

.meas tran vdout0_13ck190 FIND v(dout0_13) AT=200.05n

.meas tran vdout0_14ck190 FIND v(dout0_14) AT=200.05n

.meas tran vdout0_15ck190 FIND v(dout0_15) AT=200.05n

.meas tran vdout0_16ck190 FIND v(dout0_16) AT=200.05n

.meas tran vdout0_17ck190 FIND v(dout0_17) AT=200.05n

.meas tran vdout0_18ck190 FIND v(dout0_18) AT=200.05n

.meas tran vdout0_19ck190 FIND v(dout0_19) AT=200.05n

.meas tran vdout0_20ck190 FIND v(dout0_20) AT=200.05n

.meas tran vdout0_21ck190 FIND v(dout0_21) AT=200.05n

.meas tran vdout0_22ck190 FIND v(dout0_22) AT=200.05n

.meas tran vdout0_23ck190 FIND v(dout0_23) AT=200.05n

.meas tran vdout0_24ck190 FIND v(dout0_24) AT=200.05n

.meas tran vdout0_25ck190 FIND v(dout0_25) AT=200.05n

.meas tran vdout0_26ck190 FIND v(dout0_26) AT=200.05n

.meas tran vdout0_27ck190 FIND v(dout0_27) AT=200.05n

.meas tran vdout0_28ck190 FIND v(dout0_28) AT=200.05n

.meas tran vdout0_29ck190 FIND v(dout0_29) AT=200.05n

.meas tran vdout0_30ck190 FIND v(dout0_30) AT=200.05n

.meas tran vdout0_31ck190 FIND v(dout0_31) AT=200.05n

.meas tran vdout0_32ck190 FIND v(dout0_32) AT=200.05n

.meas tran vdout0_0ck200 FIND v(dout0_0) AT=210.05n

.meas tran vdout0_1ck200 FIND v(dout0_1) AT=210.05n

.meas tran vdout0_2ck200 FIND v(dout0_2) AT=210.05n

.meas tran vdout0_3ck200 FIND v(dout0_3) AT=210.05n

.meas tran vdout0_4ck200 FIND v(dout0_4) AT=210.05n

.meas tran vdout0_5ck200 FIND v(dout0_5) AT=210.05n

.meas tran vdout0_6ck200 FIND v(dout0_6) AT=210.05n

.meas tran vdout0_7ck200 FIND v(dout0_7) AT=210.05n

.meas tran vdout0_8ck200 FIND v(dout0_8) AT=210.05n

.meas tran vdout0_9ck200 FIND v(dout0_9) AT=210.05n

.meas tran vdout0_10ck200 FIND v(dout0_10) AT=210.05n

.meas tran vdout0_11ck200 FIND v(dout0_11) AT=210.05n

.meas tran vdout0_12ck200 FIND v(dout0_12) AT=210.05n

.meas tran vdout0_13ck200 FIND v(dout0_13) AT=210.05n

.meas tran vdout0_14ck200 FIND v(dout0_14) AT=210.05n

.meas tran vdout0_15ck200 FIND v(dout0_15) AT=210.05n

.meas tran vdout0_16ck200 FIND v(dout0_16) AT=210.05n

.meas tran vdout0_17ck200 FIND v(dout0_17) AT=210.05n

.meas tran vdout0_18ck200 FIND v(dout0_18) AT=210.05n

.meas tran vdout0_19ck200 FIND v(dout0_19) AT=210.05n

.meas tran vdout0_20ck200 FIND v(dout0_20) AT=210.05n

.meas tran vdout0_21ck200 FIND v(dout0_21) AT=210.05n

.meas tran vdout0_22ck200 FIND v(dout0_22) AT=210.05n

.meas tran vdout0_23ck200 FIND v(dout0_23) AT=210.05n

.meas tran vdout0_24ck200 FIND v(dout0_24) AT=210.05n

.meas tran vdout0_25ck200 FIND v(dout0_25) AT=210.05n

.meas tran vdout0_26ck200 FIND v(dout0_26) AT=210.05n

.meas tran vdout0_27ck200 FIND v(dout0_27) AT=210.05n

.meas tran vdout0_28ck200 FIND v(dout0_28) AT=210.05n

.meas tran vdout0_29ck200 FIND v(dout0_29) AT=210.05n

.meas tran vdout0_30ck200 FIND v(dout0_30) AT=210.05n

.meas tran vdout0_31ck200 FIND v(dout0_31) AT=210.05n

.meas tran vdout0_32ck200 FIND v(dout0_32) AT=210.05n

.meas tran vdout0_0ck210 FIND v(dout0_0) AT=220.05n

.meas tran vdout0_1ck210 FIND v(dout0_1) AT=220.05n

.meas tran vdout0_2ck210 FIND v(dout0_2) AT=220.05n

.meas tran vdout0_3ck210 FIND v(dout0_3) AT=220.05n

.meas tran vdout0_4ck210 FIND v(dout0_4) AT=220.05n

.meas tran vdout0_5ck210 FIND v(dout0_5) AT=220.05n

.meas tran vdout0_6ck210 FIND v(dout0_6) AT=220.05n

.meas tran vdout0_7ck210 FIND v(dout0_7) AT=220.05n

.meas tran vdout0_8ck210 FIND v(dout0_8) AT=220.05n

.meas tran vdout0_9ck210 FIND v(dout0_9) AT=220.05n

.meas tran vdout0_10ck210 FIND v(dout0_10) AT=220.05n

.meas tran vdout0_11ck210 FIND v(dout0_11) AT=220.05n

.meas tran vdout0_12ck210 FIND v(dout0_12) AT=220.05n

.meas tran vdout0_13ck210 FIND v(dout0_13) AT=220.05n

.meas tran vdout0_14ck210 FIND v(dout0_14) AT=220.05n

.meas tran vdout0_15ck210 FIND v(dout0_15) AT=220.05n

.meas tran vdout0_16ck210 FIND v(dout0_16) AT=220.05n

.meas tran vdout0_17ck210 FIND v(dout0_17) AT=220.05n

.meas tran vdout0_18ck210 FIND v(dout0_18) AT=220.05n

.meas tran vdout0_19ck210 FIND v(dout0_19) AT=220.05n

.meas tran vdout0_20ck210 FIND v(dout0_20) AT=220.05n

.meas tran vdout0_21ck210 FIND v(dout0_21) AT=220.05n

.meas tran vdout0_22ck210 FIND v(dout0_22) AT=220.05n

.meas tran vdout0_23ck210 FIND v(dout0_23) AT=220.05n

.meas tran vdout0_24ck210 FIND v(dout0_24) AT=220.05n

.meas tran vdout0_25ck210 FIND v(dout0_25) AT=220.05n

.meas tran vdout0_26ck210 FIND v(dout0_26) AT=220.05n

.meas tran vdout0_27ck210 FIND v(dout0_27) AT=220.05n

.meas tran vdout0_28ck210 FIND v(dout0_28) AT=220.05n

.meas tran vdout0_29ck210 FIND v(dout0_29) AT=220.05n

.meas tran vdout0_30ck210 FIND v(dout0_30) AT=220.05n

.meas tran vdout0_31ck210 FIND v(dout0_31) AT=220.05n

.meas tran vdout0_32ck210 FIND v(dout0_32) AT=220.05n

.meas tran vdout0_0ck250 FIND v(dout0_0) AT=260.05n

.meas tran vdout0_1ck250 FIND v(dout0_1) AT=260.05n

.meas tran vdout0_2ck250 FIND v(dout0_2) AT=260.05n

.meas tran vdout0_3ck250 FIND v(dout0_3) AT=260.05n

.meas tran vdout0_4ck250 FIND v(dout0_4) AT=260.05n

.meas tran vdout0_5ck250 FIND v(dout0_5) AT=260.05n

.meas tran vdout0_6ck250 FIND v(dout0_6) AT=260.05n

.meas tran vdout0_7ck250 FIND v(dout0_7) AT=260.05n

.meas tran vdout0_8ck250 FIND v(dout0_8) AT=260.05n

.meas tran vdout0_9ck250 FIND v(dout0_9) AT=260.05n

.meas tran vdout0_10ck250 FIND v(dout0_10) AT=260.05n

.meas tran vdout0_11ck250 FIND v(dout0_11) AT=260.05n

.meas tran vdout0_12ck250 FIND v(dout0_12) AT=260.05n

.meas tran vdout0_13ck250 FIND v(dout0_13) AT=260.05n

.meas tran vdout0_14ck250 FIND v(dout0_14) AT=260.05n

.meas tran vdout0_15ck250 FIND v(dout0_15) AT=260.05n

.meas tran vdout0_16ck250 FIND v(dout0_16) AT=260.05n

.meas tran vdout0_17ck250 FIND v(dout0_17) AT=260.05n

.meas tran vdout0_18ck250 FIND v(dout0_18) AT=260.05n

.meas tran vdout0_19ck250 FIND v(dout0_19) AT=260.05n

.meas tran vdout0_20ck250 FIND v(dout0_20) AT=260.05n

.meas tran vdout0_21ck250 FIND v(dout0_21) AT=260.05n

.meas tran vdout0_22ck250 FIND v(dout0_22) AT=260.05n

.meas tran vdout0_23ck250 FIND v(dout0_23) AT=260.05n

.meas tran vdout0_24ck250 FIND v(dout0_24) AT=260.05n

.meas tran vdout0_25ck250 FIND v(dout0_25) AT=260.05n

.meas tran vdout0_26ck250 FIND v(dout0_26) AT=260.05n

.meas tran vdout0_27ck250 FIND v(dout0_27) AT=260.05n

.meas tran vdout0_28ck250 FIND v(dout0_28) AT=260.05n

.meas tran vdout0_29ck250 FIND v(dout0_29) AT=260.05n

.meas tran vdout0_30ck250 FIND v(dout0_30) AT=260.05n

.meas tran vdout0_31ck250 FIND v(dout0_31) AT=260.05n

.meas tran vdout0_32ck250 FIND v(dout0_32) AT=260.05n

.meas tran vdout0_0ck260 FIND v(dout0_0) AT=270.05n

.meas tran vdout0_1ck260 FIND v(dout0_1) AT=270.05n

.meas tran vdout0_2ck260 FIND v(dout0_2) AT=270.05n

.meas tran vdout0_3ck260 FIND v(dout0_3) AT=270.05n

.meas tran vdout0_4ck260 FIND v(dout0_4) AT=270.05n

.meas tran vdout0_5ck260 FIND v(dout0_5) AT=270.05n

.meas tran vdout0_6ck260 FIND v(dout0_6) AT=270.05n

.meas tran vdout0_7ck260 FIND v(dout0_7) AT=270.05n

.meas tran vdout0_8ck260 FIND v(dout0_8) AT=270.05n

.meas tran vdout0_9ck260 FIND v(dout0_9) AT=270.05n

.meas tran vdout0_10ck260 FIND v(dout0_10) AT=270.05n

.meas tran vdout0_11ck260 FIND v(dout0_11) AT=270.05n

.meas tran vdout0_12ck260 FIND v(dout0_12) AT=270.05n

.meas tran vdout0_13ck260 FIND v(dout0_13) AT=270.05n

.meas tran vdout0_14ck260 FIND v(dout0_14) AT=270.05n

.meas tran vdout0_15ck260 FIND v(dout0_15) AT=270.05n

.meas tran vdout0_16ck260 FIND v(dout0_16) AT=270.05n

.meas tran vdout0_17ck260 FIND v(dout0_17) AT=270.05n

.meas tran vdout0_18ck260 FIND v(dout0_18) AT=270.05n

.meas tran vdout0_19ck260 FIND v(dout0_19) AT=270.05n

.meas tran vdout0_20ck260 FIND v(dout0_20) AT=270.05n

.meas tran vdout0_21ck260 FIND v(dout0_21) AT=270.05n

.meas tran vdout0_22ck260 FIND v(dout0_22) AT=270.05n

.meas tran vdout0_23ck260 FIND v(dout0_23) AT=270.05n

.meas tran vdout0_24ck260 FIND v(dout0_24) AT=270.05n

.meas tran vdout0_25ck260 FIND v(dout0_25) AT=270.05n

.meas tran vdout0_26ck260 FIND v(dout0_26) AT=270.05n

.meas tran vdout0_27ck260 FIND v(dout0_27) AT=270.05n

.meas tran vdout0_28ck260 FIND v(dout0_28) AT=270.05n

.meas tran vdout0_29ck260 FIND v(dout0_29) AT=270.05n

.meas tran vdout0_30ck260 FIND v(dout0_30) AT=270.05n

.meas tran vdout0_31ck260 FIND v(dout0_31) AT=270.05n

.meas tran vdout0_32ck260 FIND v(dout0_32) AT=270.05n

.meas tran vdout0_0ck300 FIND v(dout0_0) AT=310.05n

.meas tran vdout0_1ck300 FIND v(dout0_1) AT=310.05n

.meas tran vdout0_2ck300 FIND v(dout0_2) AT=310.05n

.meas tran vdout0_3ck300 FIND v(dout0_3) AT=310.05n

.meas tran vdout0_4ck300 FIND v(dout0_4) AT=310.05n

.meas tran vdout0_5ck300 FIND v(dout0_5) AT=310.05n

.meas tran vdout0_6ck300 FIND v(dout0_6) AT=310.05n

.meas tran vdout0_7ck300 FIND v(dout0_7) AT=310.05n

.meas tran vdout0_8ck300 FIND v(dout0_8) AT=310.05n

.meas tran vdout0_9ck300 FIND v(dout0_9) AT=310.05n

.meas tran vdout0_10ck300 FIND v(dout0_10) AT=310.05n

.meas tran vdout0_11ck300 FIND v(dout0_11) AT=310.05n

.meas tran vdout0_12ck300 FIND v(dout0_12) AT=310.05n

.meas tran vdout0_13ck300 FIND v(dout0_13) AT=310.05n

.meas tran vdout0_14ck300 FIND v(dout0_14) AT=310.05n

.meas tran vdout0_15ck300 FIND v(dout0_15) AT=310.05n

.meas tran vdout0_16ck300 FIND v(dout0_16) AT=310.05n

.meas tran vdout0_17ck300 FIND v(dout0_17) AT=310.05n

.meas tran vdout0_18ck300 FIND v(dout0_18) AT=310.05n

.meas tran vdout0_19ck300 FIND v(dout0_19) AT=310.05n

.meas tran vdout0_20ck300 FIND v(dout0_20) AT=310.05n

.meas tran vdout0_21ck300 FIND v(dout0_21) AT=310.05n

.meas tran vdout0_22ck300 FIND v(dout0_22) AT=310.05n

.meas tran vdout0_23ck300 FIND v(dout0_23) AT=310.05n

.meas tran vdout0_24ck300 FIND v(dout0_24) AT=310.05n

.meas tran vdout0_25ck300 FIND v(dout0_25) AT=310.05n

.meas tran vdout0_26ck300 FIND v(dout0_26) AT=310.05n

.meas tran vdout0_27ck300 FIND v(dout0_27) AT=310.05n

.meas tran vdout0_28ck300 FIND v(dout0_28) AT=310.05n

.meas tran vdout0_29ck300 FIND v(dout0_29) AT=310.05n

.meas tran vdout0_30ck300 FIND v(dout0_30) AT=310.05n

.meas tran vdout0_31ck300 FIND v(dout0_31) AT=310.05n

.meas tran vdout0_32ck300 FIND v(dout0_32) AT=310.05n

.meas tran vdout0_0ck320 FIND v(dout0_0) AT=330.05n

.meas tran vdout0_1ck320 FIND v(dout0_1) AT=330.05n

.meas tran vdout0_2ck320 FIND v(dout0_2) AT=330.05n

.meas tran vdout0_3ck320 FIND v(dout0_3) AT=330.05n

.meas tran vdout0_4ck320 FIND v(dout0_4) AT=330.05n

.meas tran vdout0_5ck320 FIND v(dout0_5) AT=330.05n

.meas tran vdout0_6ck320 FIND v(dout0_6) AT=330.05n

.meas tran vdout0_7ck320 FIND v(dout0_7) AT=330.05n

.meas tran vdout0_8ck320 FIND v(dout0_8) AT=330.05n

.meas tran vdout0_9ck320 FIND v(dout0_9) AT=330.05n

.meas tran vdout0_10ck320 FIND v(dout0_10) AT=330.05n

.meas tran vdout0_11ck320 FIND v(dout0_11) AT=330.05n

.meas tran vdout0_12ck320 FIND v(dout0_12) AT=330.05n

.meas tran vdout0_13ck320 FIND v(dout0_13) AT=330.05n

.meas tran vdout0_14ck320 FIND v(dout0_14) AT=330.05n

.meas tran vdout0_15ck320 FIND v(dout0_15) AT=330.05n

.meas tran vdout0_16ck320 FIND v(dout0_16) AT=330.05n

.meas tran vdout0_17ck320 FIND v(dout0_17) AT=330.05n

.meas tran vdout0_18ck320 FIND v(dout0_18) AT=330.05n

.meas tran vdout0_19ck320 FIND v(dout0_19) AT=330.05n

.meas tran vdout0_20ck320 FIND v(dout0_20) AT=330.05n

.meas tran vdout0_21ck320 FIND v(dout0_21) AT=330.05n

.meas tran vdout0_22ck320 FIND v(dout0_22) AT=330.05n

.meas tran vdout0_23ck320 FIND v(dout0_23) AT=330.05n

.meas tran vdout0_24ck320 FIND v(dout0_24) AT=330.05n

.meas tran vdout0_25ck320 FIND v(dout0_25) AT=330.05n

.meas tran vdout0_26ck320 FIND v(dout0_26) AT=330.05n

.meas tran vdout0_27ck320 FIND v(dout0_27) AT=330.05n

.meas tran vdout0_28ck320 FIND v(dout0_28) AT=330.05n

.meas tran vdout0_29ck320 FIND v(dout0_29) AT=330.05n

.meas tran vdout0_30ck320 FIND v(dout0_30) AT=330.05n

.meas tran vdout0_31ck320 FIND v(dout0_31) AT=330.05n

.meas tran vdout0_32ck320 FIND v(dout0_32) AT=330.05n

.meas tran vdout0_0ck340 FIND v(dout0_0) AT=350.05n

.meas tran vdout0_1ck340 FIND v(dout0_1) AT=350.05n

.meas tran vdout0_2ck340 FIND v(dout0_2) AT=350.05n

.meas tran vdout0_3ck340 FIND v(dout0_3) AT=350.05n

.meas tran vdout0_4ck340 FIND v(dout0_4) AT=350.05n

.meas tran vdout0_5ck340 FIND v(dout0_5) AT=350.05n

.meas tran vdout0_6ck340 FIND v(dout0_6) AT=350.05n

.meas tran vdout0_7ck340 FIND v(dout0_7) AT=350.05n

.meas tran vdout0_8ck340 FIND v(dout0_8) AT=350.05n

.meas tran vdout0_9ck340 FIND v(dout0_9) AT=350.05n

.meas tran vdout0_10ck340 FIND v(dout0_10) AT=350.05n

.meas tran vdout0_11ck340 FIND v(dout0_11) AT=350.05n

.meas tran vdout0_12ck340 FIND v(dout0_12) AT=350.05n

.meas tran vdout0_13ck340 FIND v(dout0_13) AT=350.05n

.meas tran vdout0_14ck340 FIND v(dout0_14) AT=350.05n

.meas tran vdout0_15ck340 FIND v(dout0_15) AT=350.05n

.meas tran vdout0_16ck340 FIND v(dout0_16) AT=350.05n

.meas tran vdout0_17ck340 FIND v(dout0_17) AT=350.05n

.meas tran vdout0_18ck340 FIND v(dout0_18) AT=350.05n

.meas tran vdout0_19ck340 FIND v(dout0_19) AT=350.05n

.meas tran vdout0_20ck340 FIND v(dout0_20) AT=350.05n

.meas tran vdout0_21ck340 FIND v(dout0_21) AT=350.05n

.meas tran vdout0_22ck340 FIND v(dout0_22) AT=350.05n

.meas tran vdout0_23ck340 FIND v(dout0_23) AT=350.05n

.meas tran vdout0_24ck340 FIND v(dout0_24) AT=350.05n

.meas tran vdout0_25ck340 FIND v(dout0_25) AT=350.05n

.meas tran vdout0_26ck340 FIND v(dout0_26) AT=350.05n

.meas tran vdout0_27ck340 FIND v(dout0_27) AT=350.05n

.meas tran vdout0_28ck340 FIND v(dout0_28) AT=350.05n

.meas tran vdout0_29ck340 FIND v(dout0_29) AT=350.05n

.meas tran vdout0_30ck340 FIND v(dout0_30) AT=350.05n

.meas tran vdout0_31ck340 FIND v(dout0_31) AT=350.05n

.meas tran vdout0_32ck340 FIND v(dout0_32) AT=350.05n

.meas tran vdout0_0ck360 FIND v(dout0_0) AT=370.05n

.meas tran vdout0_1ck360 FIND v(dout0_1) AT=370.05n

.meas tran vdout0_2ck360 FIND v(dout0_2) AT=370.05n

.meas tran vdout0_3ck360 FIND v(dout0_3) AT=370.05n

.meas tran vdout0_4ck360 FIND v(dout0_4) AT=370.05n

.meas tran vdout0_5ck360 FIND v(dout0_5) AT=370.05n

.meas tran vdout0_6ck360 FIND v(dout0_6) AT=370.05n

.meas tran vdout0_7ck360 FIND v(dout0_7) AT=370.05n

.meas tran vdout0_8ck360 FIND v(dout0_8) AT=370.05n

.meas tran vdout0_9ck360 FIND v(dout0_9) AT=370.05n

.meas tran vdout0_10ck360 FIND v(dout0_10) AT=370.05n

.meas tran vdout0_11ck360 FIND v(dout0_11) AT=370.05n

.meas tran vdout0_12ck360 FIND v(dout0_12) AT=370.05n

.meas tran vdout0_13ck360 FIND v(dout0_13) AT=370.05n

.meas tran vdout0_14ck360 FIND v(dout0_14) AT=370.05n

.meas tran vdout0_15ck360 FIND v(dout0_15) AT=370.05n

.meas tran vdout0_16ck360 FIND v(dout0_16) AT=370.05n

.meas tran vdout0_17ck360 FIND v(dout0_17) AT=370.05n

.meas tran vdout0_18ck360 FIND v(dout0_18) AT=370.05n

.meas tran vdout0_19ck360 FIND v(dout0_19) AT=370.05n

.meas tran vdout0_20ck360 FIND v(dout0_20) AT=370.05n

.meas tran vdout0_21ck360 FIND v(dout0_21) AT=370.05n

.meas tran vdout0_22ck360 FIND v(dout0_22) AT=370.05n

.meas tran vdout0_23ck360 FIND v(dout0_23) AT=370.05n

.meas tran vdout0_24ck360 FIND v(dout0_24) AT=370.05n

.meas tran vdout0_25ck360 FIND v(dout0_25) AT=370.05n

.meas tran vdout0_26ck360 FIND v(dout0_26) AT=370.05n

.meas tran vdout0_27ck360 FIND v(dout0_27) AT=370.05n

.meas tran vdout0_28ck360 FIND v(dout0_28) AT=370.05n

.meas tran vdout0_29ck360 FIND v(dout0_29) AT=370.05n

.meas tran vdout0_30ck360 FIND v(dout0_30) AT=370.05n

.meas tran vdout0_31ck360 FIND v(dout0_31) AT=370.05n

.meas tran vdout0_32ck360 FIND v(dout0_32) AT=370.05n

.meas tran vdout0_0ck370 FIND v(dout0_0) AT=380.05n

.meas tran vdout0_1ck370 FIND v(dout0_1) AT=380.05n

.meas tran vdout0_2ck370 FIND v(dout0_2) AT=380.05n

.meas tran vdout0_3ck370 FIND v(dout0_3) AT=380.05n

.meas tran vdout0_4ck370 FIND v(dout0_4) AT=380.05n

.meas tran vdout0_5ck370 FIND v(dout0_5) AT=380.05n

.meas tran vdout0_6ck370 FIND v(dout0_6) AT=380.05n

.meas tran vdout0_7ck370 FIND v(dout0_7) AT=380.05n

.meas tran vdout0_8ck370 FIND v(dout0_8) AT=380.05n

.meas tran vdout0_9ck370 FIND v(dout0_9) AT=380.05n

.meas tran vdout0_10ck370 FIND v(dout0_10) AT=380.05n

.meas tran vdout0_11ck370 FIND v(dout0_11) AT=380.05n

.meas tran vdout0_12ck370 FIND v(dout0_12) AT=380.05n

.meas tran vdout0_13ck370 FIND v(dout0_13) AT=380.05n

.meas tran vdout0_14ck370 FIND v(dout0_14) AT=380.05n

.meas tran vdout0_15ck370 FIND v(dout0_15) AT=380.05n

.meas tran vdout0_16ck370 FIND v(dout0_16) AT=380.05n

.meas tran vdout0_17ck370 FIND v(dout0_17) AT=380.05n

.meas tran vdout0_18ck370 FIND v(dout0_18) AT=380.05n

.meas tran vdout0_19ck370 FIND v(dout0_19) AT=380.05n

.meas tran vdout0_20ck370 FIND v(dout0_20) AT=380.05n

.meas tran vdout0_21ck370 FIND v(dout0_21) AT=380.05n

.meas tran vdout0_22ck370 FIND v(dout0_22) AT=380.05n

.meas tran vdout0_23ck370 FIND v(dout0_23) AT=380.05n

.meas tran vdout0_24ck370 FIND v(dout0_24) AT=380.05n

.meas tran vdout0_25ck370 FIND v(dout0_25) AT=380.05n

.meas tran vdout0_26ck370 FIND v(dout0_26) AT=380.05n

.meas tran vdout0_27ck370 FIND v(dout0_27) AT=380.05n

.meas tran vdout0_28ck370 FIND v(dout0_28) AT=380.05n

.meas tran vdout0_29ck370 FIND v(dout0_29) AT=380.05n

.meas tran vdout0_30ck370 FIND v(dout0_30) AT=380.05n

.meas tran vdout0_31ck370 FIND v(dout0_31) AT=380.05n

.meas tran vdout0_32ck370 FIND v(dout0_32) AT=380.05n

.meas tran vdout0_0ck400 FIND v(dout0_0) AT=410.05n

.meas tran vdout0_1ck400 FIND v(dout0_1) AT=410.05n

.meas tran vdout0_2ck400 FIND v(dout0_2) AT=410.05n

.meas tran vdout0_3ck400 FIND v(dout0_3) AT=410.05n

.meas tran vdout0_4ck400 FIND v(dout0_4) AT=410.05n

.meas tran vdout0_5ck400 FIND v(dout0_5) AT=410.05n

.meas tran vdout0_6ck400 FIND v(dout0_6) AT=410.05n

.meas tran vdout0_7ck400 FIND v(dout0_7) AT=410.05n

.meas tran vdout0_8ck400 FIND v(dout0_8) AT=410.05n

.meas tran vdout0_9ck400 FIND v(dout0_9) AT=410.05n

.meas tran vdout0_10ck400 FIND v(dout0_10) AT=410.05n

.meas tran vdout0_11ck400 FIND v(dout0_11) AT=410.05n

.meas tran vdout0_12ck400 FIND v(dout0_12) AT=410.05n

.meas tran vdout0_13ck400 FIND v(dout0_13) AT=410.05n

.meas tran vdout0_14ck400 FIND v(dout0_14) AT=410.05n

.meas tran vdout0_15ck400 FIND v(dout0_15) AT=410.05n

.meas tran vdout0_16ck400 FIND v(dout0_16) AT=410.05n

.meas tran vdout0_17ck400 FIND v(dout0_17) AT=410.05n

.meas tran vdout0_18ck400 FIND v(dout0_18) AT=410.05n

.meas tran vdout0_19ck400 FIND v(dout0_19) AT=410.05n

.meas tran vdout0_20ck400 FIND v(dout0_20) AT=410.05n

.meas tran vdout0_21ck400 FIND v(dout0_21) AT=410.05n

.meas tran vdout0_22ck400 FIND v(dout0_22) AT=410.05n

.meas tran vdout0_23ck400 FIND v(dout0_23) AT=410.05n

.meas tran vdout0_24ck400 FIND v(dout0_24) AT=410.05n

.meas tran vdout0_25ck400 FIND v(dout0_25) AT=410.05n

.meas tran vdout0_26ck400 FIND v(dout0_26) AT=410.05n

.meas tran vdout0_27ck400 FIND v(dout0_27) AT=410.05n

.meas tran vdout0_28ck400 FIND v(dout0_28) AT=410.05n

.meas tran vdout0_29ck400 FIND v(dout0_29) AT=410.05n

.meas tran vdout0_30ck400 FIND v(dout0_30) AT=410.05n

.meas tran vdout0_31ck400 FIND v(dout0_31) AT=410.05n

.meas tran vdout0_32ck400 FIND v(dout0_32) AT=410.05n

.meas tran vdout0_0ck410 FIND v(dout0_0) AT=420.05n

.meas tran vdout0_1ck410 FIND v(dout0_1) AT=420.05n

.meas tran vdout0_2ck410 FIND v(dout0_2) AT=420.05n

.meas tran vdout0_3ck410 FIND v(dout0_3) AT=420.05n

.meas tran vdout0_4ck410 FIND v(dout0_4) AT=420.05n

.meas tran vdout0_5ck410 FIND v(dout0_5) AT=420.05n

.meas tran vdout0_6ck410 FIND v(dout0_6) AT=420.05n

.meas tran vdout0_7ck410 FIND v(dout0_7) AT=420.05n

.meas tran vdout0_8ck410 FIND v(dout0_8) AT=420.05n

.meas tran vdout0_9ck410 FIND v(dout0_9) AT=420.05n

.meas tran vdout0_10ck410 FIND v(dout0_10) AT=420.05n

.meas tran vdout0_11ck410 FIND v(dout0_11) AT=420.05n

.meas tran vdout0_12ck410 FIND v(dout0_12) AT=420.05n

.meas tran vdout0_13ck410 FIND v(dout0_13) AT=420.05n

.meas tran vdout0_14ck410 FIND v(dout0_14) AT=420.05n

.meas tran vdout0_15ck410 FIND v(dout0_15) AT=420.05n

.meas tran vdout0_16ck410 FIND v(dout0_16) AT=420.05n

.meas tran vdout0_17ck410 FIND v(dout0_17) AT=420.05n

.meas tran vdout0_18ck410 FIND v(dout0_18) AT=420.05n

.meas tran vdout0_19ck410 FIND v(dout0_19) AT=420.05n

.meas tran vdout0_20ck410 FIND v(dout0_20) AT=420.05n

.meas tran vdout0_21ck410 FIND v(dout0_21) AT=420.05n

.meas tran vdout0_22ck410 FIND v(dout0_22) AT=420.05n

.meas tran vdout0_23ck410 FIND v(dout0_23) AT=420.05n

.meas tran vdout0_24ck410 FIND v(dout0_24) AT=420.05n

.meas tran vdout0_25ck410 FIND v(dout0_25) AT=420.05n

.meas tran vdout0_26ck410 FIND v(dout0_26) AT=420.05n

.meas tran vdout0_27ck410 FIND v(dout0_27) AT=420.05n

.meas tran vdout0_28ck410 FIND v(dout0_28) AT=420.05n

.meas tran vdout0_29ck410 FIND v(dout0_29) AT=420.05n

.meas tran vdout0_30ck410 FIND v(dout0_30) AT=420.05n

.meas tran vdout0_31ck410 FIND v(dout0_31) AT=420.05n

.meas tran vdout0_32ck410 FIND v(dout0_32) AT=420.05n

.meas tran vdout0_0ck450 FIND v(dout0_0) AT=460.05n

.meas tran vdout0_1ck450 FIND v(dout0_1) AT=460.05n

.meas tran vdout0_2ck450 FIND v(dout0_2) AT=460.05n

.meas tran vdout0_3ck450 FIND v(dout0_3) AT=460.05n

.meas tran vdout0_4ck450 FIND v(dout0_4) AT=460.05n

.meas tran vdout0_5ck450 FIND v(dout0_5) AT=460.05n

.meas tran vdout0_6ck450 FIND v(dout0_6) AT=460.05n

.meas tran vdout0_7ck450 FIND v(dout0_7) AT=460.05n

.meas tran vdout0_8ck450 FIND v(dout0_8) AT=460.05n

.meas tran vdout0_9ck450 FIND v(dout0_9) AT=460.05n

.meas tran vdout0_10ck450 FIND v(dout0_10) AT=460.05n

.meas tran vdout0_11ck450 FIND v(dout0_11) AT=460.05n

.meas tran vdout0_12ck450 FIND v(dout0_12) AT=460.05n

.meas tran vdout0_13ck450 FIND v(dout0_13) AT=460.05n

.meas tran vdout0_14ck450 FIND v(dout0_14) AT=460.05n

.meas tran vdout0_15ck450 FIND v(dout0_15) AT=460.05n

.meas tran vdout0_16ck450 FIND v(dout0_16) AT=460.05n

.meas tran vdout0_17ck450 FIND v(dout0_17) AT=460.05n

.meas tran vdout0_18ck450 FIND v(dout0_18) AT=460.05n

.meas tran vdout0_19ck450 FIND v(dout0_19) AT=460.05n

.meas tran vdout0_20ck450 FIND v(dout0_20) AT=460.05n

.meas tran vdout0_21ck450 FIND v(dout0_21) AT=460.05n

.meas tran vdout0_22ck450 FIND v(dout0_22) AT=460.05n

.meas tran vdout0_23ck450 FIND v(dout0_23) AT=460.05n

.meas tran vdout0_24ck450 FIND v(dout0_24) AT=460.05n

.meas tran vdout0_25ck450 FIND v(dout0_25) AT=460.05n

.meas tran vdout0_26ck450 FIND v(dout0_26) AT=460.05n

.meas tran vdout0_27ck450 FIND v(dout0_27) AT=460.05n

.meas tran vdout0_28ck450 FIND v(dout0_28) AT=460.05n

.meas tran vdout0_29ck450 FIND v(dout0_29) AT=460.05n

.meas tran vdout0_30ck450 FIND v(dout0_30) AT=460.05n

.meas tran vdout0_31ck450 FIND v(dout0_31) AT=460.05n

.meas tran vdout0_32ck450 FIND v(dout0_32) AT=460.05n

.meas tran vdout0_0ck460 FIND v(dout0_0) AT=470.05n

.meas tran vdout0_1ck460 FIND v(dout0_1) AT=470.05n

.meas tran vdout0_2ck460 FIND v(dout0_2) AT=470.05n

.meas tran vdout0_3ck460 FIND v(dout0_3) AT=470.05n

.meas tran vdout0_4ck460 FIND v(dout0_4) AT=470.05n

.meas tran vdout0_5ck460 FIND v(dout0_5) AT=470.05n

.meas tran vdout0_6ck460 FIND v(dout0_6) AT=470.05n

.meas tran vdout0_7ck460 FIND v(dout0_7) AT=470.05n

.meas tran vdout0_8ck460 FIND v(dout0_8) AT=470.05n

.meas tran vdout0_9ck460 FIND v(dout0_9) AT=470.05n

.meas tran vdout0_10ck460 FIND v(dout0_10) AT=470.05n

.meas tran vdout0_11ck460 FIND v(dout0_11) AT=470.05n

.meas tran vdout0_12ck460 FIND v(dout0_12) AT=470.05n

.meas tran vdout0_13ck460 FIND v(dout0_13) AT=470.05n

.meas tran vdout0_14ck460 FIND v(dout0_14) AT=470.05n

.meas tran vdout0_15ck460 FIND v(dout0_15) AT=470.05n

.meas tran vdout0_16ck460 FIND v(dout0_16) AT=470.05n

.meas tran vdout0_17ck460 FIND v(dout0_17) AT=470.05n

.meas tran vdout0_18ck460 FIND v(dout0_18) AT=470.05n

.meas tran vdout0_19ck460 FIND v(dout0_19) AT=470.05n

.meas tran vdout0_20ck460 FIND v(dout0_20) AT=470.05n

.meas tran vdout0_21ck460 FIND v(dout0_21) AT=470.05n

.meas tran vdout0_22ck460 FIND v(dout0_22) AT=470.05n

.meas tran vdout0_23ck460 FIND v(dout0_23) AT=470.05n

.meas tran vdout0_24ck460 FIND v(dout0_24) AT=470.05n

.meas tran vdout0_25ck460 FIND v(dout0_25) AT=470.05n

.meas tran vdout0_26ck460 FIND v(dout0_26) AT=470.05n

.meas tran vdout0_27ck460 FIND v(dout0_27) AT=470.05n

.meas tran vdout0_28ck460 FIND v(dout0_28) AT=470.05n

.meas tran vdout0_29ck460 FIND v(dout0_29) AT=470.05n

.meas tran vdout0_30ck460 FIND v(dout0_30) AT=470.05n

.meas tran vdout0_31ck460 FIND v(dout0_31) AT=470.05n

.meas tran vdout0_32ck460 FIND v(dout0_32) AT=470.05n

.meas tran vdout0_0ck490 FIND v(dout0_0) AT=500.05n

.meas tran vdout0_1ck490 FIND v(dout0_1) AT=500.05n

.meas tran vdout0_2ck490 FIND v(dout0_2) AT=500.05n

.meas tran vdout0_3ck490 FIND v(dout0_3) AT=500.05n

.meas tran vdout0_4ck490 FIND v(dout0_4) AT=500.05n

.meas tran vdout0_5ck490 FIND v(dout0_5) AT=500.05n

.meas tran vdout0_6ck490 FIND v(dout0_6) AT=500.05n

.meas tran vdout0_7ck490 FIND v(dout0_7) AT=500.05n

.meas tran vdout0_8ck490 FIND v(dout0_8) AT=500.05n

.meas tran vdout0_9ck490 FIND v(dout0_9) AT=500.05n

.meas tran vdout0_10ck490 FIND v(dout0_10) AT=500.05n

.meas tran vdout0_11ck490 FIND v(dout0_11) AT=500.05n

.meas tran vdout0_12ck490 FIND v(dout0_12) AT=500.05n

.meas tran vdout0_13ck490 FIND v(dout0_13) AT=500.05n

.meas tran vdout0_14ck490 FIND v(dout0_14) AT=500.05n

.meas tran vdout0_15ck490 FIND v(dout0_15) AT=500.05n

.meas tran vdout0_16ck490 FIND v(dout0_16) AT=500.05n

.meas tran vdout0_17ck490 FIND v(dout0_17) AT=500.05n

.meas tran vdout0_18ck490 FIND v(dout0_18) AT=500.05n

.meas tran vdout0_19ck490 FIND v(dout0_19) AT=500.05n

.meas tran vdout0_20ck490 FIND v(dout0_20) AT=500.05n

.meas tran vdout0_21ck490 FIND v(dout0_21) AT=500.05n

.meas tran vdout0_22ck490 FIND v(dout0_22) AT=500.05n

.meas tran vdout0_23ck490 FIND v(dout0_23) AT=500.05n

.meas tran vdout0_24ck490 FIND v(dout0_24) AT=500.05n

.meas tran vdout0_25ck490 FIND v(dout0_25) AT=500.05n

.meas tran vdout0_26ck490 FIND v(dout0_26) AT=500.05n

.meas tran vdout0_27ck490 FIND v(dout0_27) AT=500.05n

.meas tran vdout0_28ck490 FIND v(dout0_28) AT=500.05n

.meas tran vdout0_29ck490 FIND v(dout0_29) AT=500.05n

.meas tran vdout0_30ck490 FIND v(dout0_30) AT=500.05n

.meas tran vdout0_31ck490 FIND v(dout0_31) AT=500.05n

.meas tran vdout0_32ck490 FIND v(dout0_32) AT=500.05n

.meas tran vdout0_0ck500 FIND v(dout0_0) AT=510.05n

.meas tran vdout0_1ck500 FIND v(dout0_1) AT=510.05n

.meas tran vdout0_2ck500 FIND v(dout0_2) AT=510.05n

.meas tran vdout0_3ck500 FIND v(dout0_3) AT=510.05n

.meas tran vdout0_4ck500 FIND v(dout0_4) AT=510.05n

.meas tran vdout0_5ck500 FIND v(dout0_5) AT=510.05n

.meas tran vdout0_6ck500 FIND v(dout0_6) AT=510.05n

.meas tran vdout0_7ck500 FIND v(dout0_7) AT=510.05n

.meas tran vdout0_8ck500 FIND v(dout0_8) AT=510.05n

.meas tran vdout0_9ck500 FIND v(dout0_9) AT=510.05n

.meas tran vdout0_10ck500 FIND v(dout0_10) AT=510.05n

.meas tran vdout0_11ck500 FIND v(dout0_11) AT=510.05n

.meas tran vdout0_12ck500 FIND v(dout0_12) AT=510.05n

.meas tran vdout0_13ck500 FIND v(dout0_13) AT=510.05n

.meas tran vdout0_14ck500 FIND v(dout0_14) AT=510.05n

.meas tran vdout0_15ck500 FIND v(dout0_15) AT=510.05n

.meas tran vdout0_16ck500 FIND v(dout0_16) AT=510.05n

.meas tran vdout0_17ck500 FIND v(dout0_17) AT=510.05n

.meas tran vdout0_18ck500 FIND v(dout0_18) AT=510.05n

.meas tran vdout0_19ck500 FIND v(dout0_19) AT=510.05n

.meas tran vdout0_20ck500 FIND v(dout0_20) AT=510.05n

.meas tran vdout0_21ck500 FIND v(dout0_21) AT=510.05n

.meas tran vdout0_22ck500 FIND v(dout0_22) AT=510.05n

.meas tran vdout0_23ck500 FIND v(dout0_23) AT=510.05n

.meas tran vdout0_24ck500 FIND v(dout0_24) AT=510.05n

.meas tran vdout0_25ck500 FIND v(dout0_25) AT=510.05n

.meas tran vdout0_26ck500 FIND v(dout0_26) AT=510.05n

.meas tran vdout0_27ck500 FIND v(dout0_27) AT=510.05n

.meas tran vdout0_28ck500 FIND v(dout0_28) AT=510.05n

.meas tran vdout0_29ck500 FIND v(dout0_29) AT=510.05n

.meas tran vdout0_30ck500 FIND v(dout0_30) AT=510.05n

.meas tran vdout0_31ck500 FIND v(dout0_31) AT=510.05n

.meas tran vdout0_32ck500 FIND v(dout0_32) AT=510.05n

.meas tran vdout0_0ck510 FIND v(dout0_0) AT=520.05n

.meas tran vdout0_1ck510 FIND v(dout0_1) AT=520.05n

.meas tran vdout0_2ck510 FIND v(dout0_2) AT=520.05n

.meas tran vdout0_3ck510 FIND v(dout0_3) AT=520.05n

.meas tran vdout0_4ck510 FIND v(dout0_4) AT=520.05n

.meas tran vdout0_5ck510 FIND v(dout0_5) AT=520.05n

.meas tran vdout0_6ck510 FIND v(dout0_6) AT=520.05n

.meas tran vdout0_7ck510 FIND v(dout0_7) AT=520.05n

.meas tran vdout0_8ck510 FIND v(dout0_8) AT=520.05n

.meas tran vdout0_9ck510 FIND v(dout0_9) AT=520.05n

.meas tran vdout0_10ck510 FIND v(dout0_10) AT=520.05n

.meas tran vdout0_11ck510 FIND v(dout0_11) AT=520.05n

.meas tran vdout0_12ck510 FIND v(dout0_12) AT=520.05n

.meas tran vdout0_13ck510 FIND v(dout0_13) AT=520.05n

.meas tran vdout0_14ck510 FIND v(dout0_14) AT=520.05n

.meas tran vdout0_15ck510 FIND v(dout0_15) AT=520.05n

.meas tran vdout0_16ck510 FIND v(dout0_16) AT=520.05n

.meas tran vdout0_17ck510 FIND v(dout0_17) AT=520.05n

.meas tran vdout0_18ck510 FIND v(dout0_18) AT=520.05n

.meas tran vdout0_19ck510 FIND v(dout0_19) AT=520.05n

.meas tran vdout0_20ck510 FIND v(dout0_20) AT=520.05n

.meas tran vdout0_21ck510 FIND v(dout0_21) AT=520.05n

.meas tran vdout0_22ck510 FIND v(dout0_22) AT=520.05n

.meas tran vdout0_23ck510 FIND v(dout0_23) AT=520.05n

.meas tran vdout0_24ck510 FIND v(dout0_24) AT=520.05n

.meas tran vdout0_25ck510 FIND v(dout0_25) AT=520.05n

.meas tran vdout0_26ck510 FIND v(dout0_26) AT=520.05n

.meas tran vdout0_27ck510 FIND v(dout0_27) AT=520.05n

.meas tran vdout0_28ck510 FIND v(dout0_28) AT=520.05n

.meas tran vdout0_29ck510 FIND v(dout0_29) AT=520.05n

.meas tran vdout0_30ck510 FIND v(dout0_30) AT=520.05n

.meas tran vdout0_31ck510 FIND v(dout0_31) AT=520.05n

.meas tran vdout0_32ck510 FIND v(dout0_32) AT=520.05n

.meas tran vdout0_0ck520 FIND v(dout0_0) AT=530.05n

.meas tran vdout0_1ck520 FIND v(dout0_1) AT=530.05n

.meas tran vdout0_2ck520 FIND v(dout0_2) AT=530.05n

.meas tran vdout0_3ck520 FIND v(dout0_3) AT=530.05n

.meas tran vdout0_4ck520 FIND v(dout0_4) AT=530.05n

.meas tran vdout0_5ck520 FIND v(dout0_5) AT=530.05n

.meas tran vdout0_6ck520 FIND v(dout0_6) AT=530.05n

.meas tran vdout0_7ck520 FIND v(dout0_7) AT=530.05n

.meas tran vdout0_8ck520 FIND v(dout0_8) AT=530.05n

.meas tran vdout0_9ck520 FIND v(dout0_9) AT=530.05n

.meas tran vdout0_10ck520 FIND v(dout0_10) AT=530.05n

.meas tran vdout0_11ck520 FIND v(dout0_11) AT=530.05n

.meas tran vdout0_12ck520 FIND v(dout0_12) AT=530.05n

.meas tran vdout0_13ck520 FIND v(dout0_13) AT=530.05n

.meas tran vdout0_14ck520 FIND v(dout0_14) AT=530.05n

.meas tran vdout0_15ck520 FIND v(dout0_15) AT=530.05n

.meas tran vdout0_16ck520 FIND v(dout0_16) AT=530.05n

.meas tran vdout0_17ck520 FIND v(dout0_17) AT=530.05n

.meas tran vdout0_18ck520 FIND v(dout0_18) AT=530.05n

.meas tran vdout0_19ck520 FIND v(dout0_19) AT=530.05n

.meas tran vdout0_20ck520 FIND v(dout0_20) AT=530.05n

.meas tran vdout0_21ck520 FIND v(dout0_21) AT=530.05n

.meas tran vdout0_22ck520 FIND v(dout0_22) AT=530.05n

.meas tran vdout0_23ck520 FIND v(dout0_23) AT=530.05n

.meas tran vdout0_24ck520 FIND v(dout0_24) AT=530.05n

.meas tran vdout0_25ck520 FIND v(dout0_25) AT=530.05n

.meas tran vdout0_26ck520 FIND v(dout0_26) AT=530.05n

.meas tran vdout0_27ck520 FIND v(dout0_27) AT=530.05n

.meas tran vdout0_28ck520 FIND v(dout0_28) AT=530.05n

.meas tran vdout0_29ck520 FIND v(dout0_29) AT=530.05n

.meas tran vdout0_30ck520 FIND v(dout0_30) AT=530.05n

.meas tran vdout0_31ck520 FIND v(dout0_31) AT=530.05n

.meas tran vdout0_32ck520 FIND v(dout0_32) AT=530.05n

.meas tran vdout0_0ck530 FIND v(dout0_0) AT=540.05n

.meas tran vdout0_1ck530 FIND v(dout0_1) AT=540.05n

.meas tran vdout0_2ck530 FIND v(dout0_2) AT=540.05n

.meas tran vdout0_3ck530 FIND v(dout0_3) AT=540.05n

.meas tran vdout0_4ck530 FIND v(dout0_4) AT=540.05n

.meas tran vdout0_5ck530 FIND v(dout0_5) AT=540.05n

.meas tran vdout0_6ck530 FIND v(dout0_6) AT=540.05n

.meas tran vdout0_7ck530 FIND v(dout0_7) AT=540.05n

.meas tran vdout0_8ck530 FIND v(dout0_8) AT=540.05n

.meas tran vdout0_9ck530 FIND v(dout0_9) AT=540.05n

.meas tran vdout0_10ck530 FIND v(dout0_10) AT=540.05n

.meas tran vdout0_11ck530 FIND v(dout0_11) AT=540.05n

.meas tran vdout0_12ck530 FIND v(dout0_12) AT=540.05n

.meas tran vdout0_13ck530 FIND v(dout0_13) AT=540.05n

.meas tran vdout0_14ck530 FIND v(dout0_14) AT=540.05n

.meas tran vdout0_15ck530 FIND v(dout0_15) AT=540.05n

.meas tran vdout0_16ck530 FIND v(dout0_16) AT=540.05n

.meas tran vdout0_17ck530 FIND v(dout0_17) AT=540.05n

.meas tran vdout0_18ck530 FIND v(dout0_18) AT=540.05n

.meas tran vdout0_19ck530 FIND v(dout0_19) AT=540.05n

.meas tran vdout0_20ck530 FIND v(dout0_20) AT=540.05n

.meas tran vdout0_21ck530 FIND v(dout0_21) AT=540.05n

.meas tran vdout0_22ck530 FIND v(dout0_22) AT=540.05n

.meas tran vdout0_23ck530 FIND v(dout0_23) AT=540.05n

.meas tran vdout0_24ck530 FIND v(dout0_24) AT=540.05n

.meas tran vdout0_25ck530 FIND v(dout0_25) AT=540.05n

.meas tran vdout0_26ck530 FIND v(dout0_26) AT=540.05n

.meas tran vdout0_27ck530 FIND v(dout0_27) AT=540.05n

.meas tran vdout0_28ck530 FIND v(dout0_28) AT=540.05n

.meas tran vdout0_29ck530 FIND v(dout0_29) AT=540.05n

.meas tran vdout0_30ck530 FIND v(dout0_30) AT=540.05n

.meas tran vdout0_31ck530 FIND v(dout0_31) AT=540.05n

.meas tran vdout0_32ck530 FIND v(dout0_32) AT=540.05n

.meas tran vdout0_0ck600 FIND v(dout0_0) AT=610.05n

.meas tran vdout0_1ck600 FIND v(dout0_1) AT=610.05n

.meas tran vdout0_2ck600 FIND v(dout0_2) AT=610.05n

.meas tran vdout0_3ck600 FIND v(dout0_3) AT=610.05n

.meas tran vdout0_4ck600 FIND v(dout0_4) AT=610.05n

.meas tran vdout0_5ck600 FIND v(dout0_5) AT=610.05n

.meas tran vdout0_6ck600 FIND v(dout0_6) AT=610.05n

.meas tran vdout0_7ck600 FIND v(dout0_7) AT=610.05n

.meas tran vdout0_8ck600 FIND v(dout0_8) AT=610.05n

.meas tran vdout0_9ck600 FIND v(dout0_9) AT=610.05n

.meas tran vdout0_10ck600 FIND v(dout0_10) AT=610.05n

.meas tran vdout0_11ck600 FIND v(dout0_11) AT=610.05n

.meas tran vdout0_12ck600 FIND v(dout0_12) AT=610.05n

.meas tran vdout0_13ck600 FIND v(dout0_13) AT=610.05n

.meas tran vdout0_14ck600 FIND v(dout0_14) AT=610.05n

.meas tran vdout0_15ck600 FIND v(dout0_15) AT=610.05n

.meas tran vdout0_16ck600 FIND v(dout0_16) AT=610.05n

.meas tran vdout0_17ck600 FIND v(dout0_17) AT=610.05n

.meas tran vdout0_18ck600 FIND v(dout0_18) AT=610.05n

.meas tran vdout0_19ck600 FIND v(dout0_19) AT=610.05n

.meas tran vdout0_20ck600 FIND v(dout0_20) AT=610.05n

.meas tran vdout0_21ck600 FIND v(dout0_21) AT=610.05n

.meas tran vdout0_22ck600 FIND v(dout0_22) AT=610.05n

.meas tran vdout0_23ck600 FIND v(dout0_23) AT=610.05n

.meas tran vdout0_24ck600 FIND v(dout0_24) AT=610.05n

.meas tran vdout0_25ck600 FIND v(dout0_25) AT=610.05n

.meas tran vdout0_26ck600 FIND v(dout0_26) AT=610.05n

.meas tran vdout0_27ck600 FIND v(dout0_27) AT=610.05n

.meas tran vdout0_28ck600 FIND v(dout0_28) AT=610.05n

.meas tran vdout0_29ck600 FIND v(dout0_29) AT=610.05n

.meas tran vdout0_30ck600 FIND v(dout0_30) AT=610.05n

.meas tran vdout0_31ck600 FIND v(dout0_31) AT=610.05n

.meas tran vdout0_32ck600 FIND v(dout0_32) AT=610.05n

.meas tran vdout0_0ck610 FIND v(dout0_0) AT=620.05n

.meas tran vdout0_1ck610 FIND v(dout0_1) AT=620.05n

.meas tran vdout0_2ck610 FIND v(dout0_2) AT=620.05n

.meas tran vdout0_3ck610 FIND v(dout0_3) AT=620.05n

.meas tran vdout0_4ck610 FIND v(dout0_4) AT=620.05n

.meas tran vdout0_5ck610 FIND v(dout0_5) AT=620.05n

.meas tran vdout0_6ck610 FIND v(dout0_6) AT=620.05n

.meas tran vdout0_7ck610 FIND v(dout0_7) AT=620.05n

.meas tran vdout0_8ck610 FIND v(dout0_8) AT=620.05n

.meas tran vdout0_9ck610 FIND v(dout0_9) AT=620.05n

.meas tran vdout0_10ck610 FIND v(dout0_10) AT=620.05n

.meas tran vdout0_11ck610 FIND v(dout0_11) AT=620.05n

.meas tran vdout0_12ck610 FIND v(dout0_12) AT=620.05n

.meas tran vdout0_13ck610 FIND v(dout0_13) AT=620.05n

.meas tran vdout0_14ck610 FIND v(dout0_14) AT=620.05n

.meas tran vdout0_15ck610 FIND v(dout0_15) AT=620.05n

.meas tran vdout0_16ck610 FIND v(dout0_16) AT=620.05n

.meas tran vdout0_17ck610 FIND v(dout0_17) AT=620.05n

.meas tran vdout0_18ck610 FIND v(dout0_18) AT=620.05n

.meas tran vdout0_19ck610 FIND v(dout0_19) AT=620.05n

.meas tran vdout0_20ck610 FIND v(dout0_20) AT=620.05n

.meas tran vdout0_21ck610 FIND v(dout0_21) AT=620.05n

.meas tran vdout0_22ck610 FIND v(dout0_22) AT=620.05n

.meas tran vdout0_23ck610 FIND v(dout0_23) AT=620.05n

.meas tran vdout0_24ck610 FIND v(dout0_24) AT=620.05n

.meas tran vdout0_25ck610 FIND v(dout0_25) AT=620.05n

.meas tran vdout0_26ck610 FIND v(dout0_26) AT=620.05n

.meas tran vdout0_27ck610 FIND v(dout0_27) AT=620.05n

.meas tran vdout0_28ck610 FIND v(dout0_28) AT=620.05n

.meas tran vdout0_29ck610 FIND v(dout0_29) AT=620.05n

.meas tran vdout0_30ck610 FIND v(dout0_30) AT=620.05n

.meas tran vdout0_31ck610 FIND v(dout0_31) AT=620.05n

.meas tran vdout0_32ck610 FIND v(dout0_32) AT=620.05n

.meas tran vdout0_0ck650 FIND v(dout0_0) AT=660.05n

.meas tran vdout0_1ck650 FIND v(dout0_1) AT=660.05n

.meas tran vdout0_2ck650 FIND v(dout0_2) AT=660.05n

.meas tran vdout0_3ck650 FIND v(dout0_3) AT=660.05n

.meas tran vdout0_4ck650 FIND v(dout0_4) AT=660.05n

.meas tran vdout0_5ck650 FIND v(dout0_5) AT=660.05n

.meas tran vdout0_6ck650 FIND v(dout0_6) AT=660.05n

.meas tran vdout0_7ck650 FIND v(dout0_7) AT=660.05n

.meas tran vdout0_8ck650 FIND v(dout0_8) AT=660.05n

.meas tran vdout0_9ck650 FIND v(dout0_9) AT=660.05n

.meas tran vdout0_10ck650 FIND v(dout0_10) AT=660.05n

.meas tran vdout0_11ck650 FIND v(dout0_11) AT=660.05n

.meas tran vdout0_12ck650 FIND v(dout0_12) AT=660.05n

.meas tran vdout0_13ck650 FIND v(dout0_13) AT=660.05n

.meas tran vdout0_14ck650 FIND v(dout0_14) AT=660.05n

.meas tran vdout0_15ck650 FIND v(dout0_15) AT=660.05n

.meas tran vdout0_16ck650 FIND v(dout0_16) AT=660.05n

.meas tran vdout0_17ck650 FIND v(dout0_17) AT=660.05n

.meas tran vdout0_18ck650 FIND v(dout0_18) AT=660.05n

.meas tran vdout0_19ck650 FIND v(dout0_19) AT=660.05n

.meas tran vdout0_20ck650 FIND v(dout0_20) AT=660.05n

.meas tran vdout0_21ck650 FIND v(dout0_21) AT=660.05n

.meas tran vdout0_22ck650 FIND v(dout0_22) AT=660.05n

.meas tran vdout0_23ck650 FIND v(dout0_23) AT=660.05n

.meas tran vdout0_24ck650 FIND v(dout0_24) AT=660.05n

.meas tran vdout0_25ck650 FIND v(dout0_25) AT=660.05n

.meas tran vdout0_26ck650 FIND v(dout0_26) AT=660.05n

.meas tran vdout0_27ck650 FIND v(dout0_27) AT=660.05n

.meas tran vdout0_28ck650 FIND v(dout0_28) AT=660.05n

.meas tran vdout0_29ck650 FIND v(dout0_29) AT=660.05n

.meas tran vdout0_30ck650 FIND v(dout0_30) AT=660.05n

.meas tran vdout0_31ck650 FIND v(dout0_31) AT=660.05n

.meas tran vdout0_32ck650 FIND v(dout0_32) AT=660.05n

.meas tran vdout0_0ck670 FIND v(dout0_0) AT=680.05n

.meas tran vdout0_1ck670 FIND v(dout0_1) AT=680.05n

.meas tran vdout0_2ck670 FIND v(dout0_2) AT=680.05n

.meas tran vdout0_3ck670 FIND v(dout0_3) AT=680.05n

.meas tran vdout0_4ck670 FIND v(dout0_4) AT=680.05n

.meas tran vdout0_5ck670 FIND v(dout0_5) AT=680.05n

.meas tran vdout0_6ck670 FIND v(dout0_6) AT=680.05n

.meas tran vdout0_7ck670 FIND v(dout0_7) AT=680.05n

.meas tran vdout0_8ck670 FIND v(dout0_8) AT=680.05n

.meas tran vdout0_9ck670 FIND v(dout0_9) AT=680.05n

.meas tran vdout0_10ck670 FIND v(dout0_10) AT=680.05n

.meas tran vdout0_11ck670 FIND v(dout0_11) AT=680.05n

.meas tran vdout0_12ck670 FIND v(dout0_12) AT=680.05n

.meas tran vdout0_13ck670 FIND v(dout0_13) AT=680.05n

.meas tran vdout0_14ck670 FIND v(dout0_14) AT=680.05n

.meas tran vdout0_15ck670 FIND v(dout0_15) AT=680.05n

.meas tran vdout0_16ck670 FIND v(dout0_16) AT=680.05n

.meas tran vdout0_17ck670 FIND v(dout0_17) AT=680.05n

.meas tran vdout0_18ck670 FIND v(dout0_18) AT=680.05n

.meas tran vdout0_19ck670 FIND v(dout0_19) AT=680.05n

.meas tran vdout0_20ck670 FIND v(dout0_20) AT=680.05n

.meas tran vdout0_21ck670 FIND v(dout0_21) AT=680.05n

.meas tran vdout0_22ck670 FIND v(dout0_22) AT=680.05n

.meas tran vdout0_23ck670 FIND v(dout0_23) AT=680.05n

.meas tran vdout0_24ck670 FIND v(dout0_24) AT=680.05n

.meas tran vdout0_25ck670 FIND v(dout0_25) AT=680.05n

.meas tran vdout0_26ck670 FIND v(dout0_26) AT=680.05n

.meas tran vdout0_27ck670 FIND v(dout0_27) AT=680.05n

.meas tran vdout0_28ck670 FIND v(dout0_28) AT=680.05n

.meas tran vdout0_29ck670 FIND v(dout0_29) AT=680.05n

.meas tran vdout0_30ck670 FIND v(dout0_30) AT=680.05n

.meas tran vdout0_31ck670 FIND v(dout0_31) AT=680.05n

.meas tran vdout0_32ck670 FIND v(dout0_32) AT=680.05n

.meas tran vdout0_0ck680 FIND v(dout0_0) AT=690.05n

.meas tran vdout0_1ck680 FIND v(dout0_1) AT=690.05n

.meas tran vdout0_2ck680 FIND v(dout0_2) AT=690.05n

.meas tran vdout0_3ck680 FIND v(dout0_3) AT=690.05n

.meas tran vdout0_4ck680 FIND v(dout0_4) AT=690.05n

.meas tran vdout0_5ck680 FIND v(dout0_5) AT=690.05n

.meas tran vdout0_6ck680 FIND v(dout0_6) AT=690.05n

.meas tran vdout0_7ck680 FIND v(dout0_7) AT=690.05n

.meas tran vdout0_8ck680 FIND v(dout0_8) AT=690.05n

.meas tran vdout0_9ck680 FIND v(dout0_9) AT=690.05n

.meas tran vdout0_10ck680 FIND v(dout0_10) AT=690.05n

.meas tran vdout0_11ck680 FIND v(dout0_11) AT=690.05n

.meas tran vdout0_12ck680 FIND v(dout0_12) AT=690.05n

.meas tran vdout0_13ck680 FIND v(dout0_13) AT=690.05n

.meas tran vdout0_14ck680 FIND v(dout0_14) AT=690.05n

.meas tran vdout0_15ck680 FIND v(dout0_15) AT=690.05n

.meas tran vdout0_16ck680 FIND v(dout0_16) AT=690.05n

.meas tran vdout0_17ck680 FIND v(dout0_17) AT=690.05n

.meas tran vdout0_18ck680 FIND v(dout0_18) AT=690.05n

.meas tran vdout0_19ck680 FIND v(dout0_19) AT=690.05n

.meas tran vdout0_20ck680 FIND v(dout0_20) AT=690.05n

.meas tran vdout0_21ck680 FIND v(dout0_21) AT=690.05n

.meas tran vdout0_22ck680 FIND v(dout0_22) AT=690.05n

.meas tran vdout0_23ck680 FIND v(dout0_23) AT=690.05n

.meas tran vdout0_24ck680 FIND v(dout0_24) AT=690.05n

.meas tran vdout0_25ck680 FIND v(dout0_25) AT=690.05n

.meas tran vdout0_26ck680 FIND v(dout0_26) AT=690.05n

.meas tran vdout0_27ck680 FIND v(dout0_27) AT=690.05n

.meas tran vdout0_28ck680 FIND v(dout0_28) AT=690.05n

.meas tran vdout0_29ck680 FIND v(dout0_29) AT=690.05n

.meas tran vdout0_30ck680 FIND v(dout0_30) AT=690.05n

.meas tran vdout0_31ck680 FIND v(dout0_31) AT=690.05n

.meas tran vdout0_32ck680 FIND v(dout0_32) AT=690.05n

.meas tran vdout0_0ck740 FIND v(dout0_0) AT=750.05n

.meas tran vdout0_1ck740 FIND v(dout0_1) AT=750.05n

.meas tran vdout0_2ck740 FIND v(dout0_2) AT=750.05n

.meas tran vdout0_3ck740 FIND v(dout0_3) AT=750.05n

.meas tran vdout0_4ck740 FIND v(dout0_4) AT=750.05n

.meas tran vdout0_5ck740 FIND v(dout0_5) AT=750.05n

.meas tran vdout0_6ck740 FIND v(dout0_6) AT=750.05n

.meas tran vdout0_7ck740 FIND v(dout0_7) AT=750.05n

.meas tran vdout0_8ck740 FIND v(dout0_8) AT=750.05n

.meas tran vdout0_9ck740 FIND v(dout0_9) AT=750.05n

.meas tran vdout0_10ck740 FIND v(dout0_10) AT=750.05n

.meas tran vdout0_11ck740 FIND v(dout0_11) AT=750.05n

.meas tran vdout0_12ck740 FIND v(dout0_12) AT=750.05n

.meas tran vdout0_13ck740 FIND v(dout0_13) AT=750.05n

.meas tran vdout0_14ck740 FIND v(dout0_14) AT=750.05n

.meas tran vdout0_15ck740 FIND v(dout0_15) AT=750.05n

.meas tran vdout0_16ck740 FIND v(dout0_16) AT=750.05n

.meas tran vdout0_17ck740 FIND v(dout0_17) AT=750.05n

.meas tran vdout0_18ck740 FIND v(dout0_18) AT=750.05n

.meas tran vdout0_19ck740 FIND v(dout0_19) AT=750.05n

.meas tran vdout0_20ck740 FIND v(dout0_20) AT=750.05n

.meas tran vdout0_21ck740 FIND v(dout0_21) AT=750.05n

.meas tran vdout0_22ck740 FIND v(dout0_22) AT=750.05n

.meas tran vdout0_23ck740 FIND v(dout0_23) AT=750.05n

.meas tran vdout0_24ck740 FIND v(dout0_24) AT=750.05n

.meas tran vdout0_25ck740 FIND v(dout0_25) AT=750.05n

.meas tran vdout0_26ck740 FIND v(dout0_26) AT=750.05n

.meas tran vdout0_27ck740 FIND v(dout0_27) AT=750.05n

.meas tran vdout0_28ck740 FIND v(dout0_28) AT=750.05n

.meas tran vdout0_29ck740 FIND v(dout0_29) AT=750.05n

.meas tran vdout0_30ck740 FIND v(dout0_30) AT=750.05n

.meas tran vdout0_31ck740 FIND v(dout0_31) AT=750.05n

.meas tran vdout0_32ck740 FIND v(dout0_32) AT=750.05n

.meas tran vdout0_0ck810 FIND v(dout0_0) AT=820.05n

.meas tran vdout0_1ck810 FIND v(dout0_1) AT=820.05n

.meas tran vdout0_2ck810 FIND v(dout0_2) AT=820.05n

.meas tran vdout0_3ck810 FIND v(dout0_3) AT=820.05n

.meas tran vdout0_4ck810 FIND v(dout0_4) AT=820.05n

.meas tran vdout0_5ck810 FIND v(dout0_5) AT=820.05n

.meas tran vdout0_6ck810 FIND v(dout0_6) AT=820.05n

.meas tran vdout0_7ck810 FIND v(dout0_7) AT=820.05n

.meas tran vdout0_8ck810 FIND v(dout0_8) AT=820.05n

.meas tran vdout0_9ck810 FIND v(dout0_9) AT=820.05n

.meas tran vdout0_10ck810 FIND v(dout0_10) AT=820.05n

.meas tran vdout0_11ck810 FIND v(dout0_11) AT=820.05n

.meas tran vdout0_12ck810 FIND v(dout0_12) AT=820.05n

.meas tran vdout0_13ck810 FIND v(dout0_13) AT=820.05n

.meas tran vdout0_14ck810 FIND v(dout0_14) AT=820.05n

.meas tran vdout0_15ck810 FIND v(dout0_15) AT=820.05n

.meas tran vdout0_16ck810 FIND v(dout0_16) AT=820.05n

.meas tran vdout0_17ck810 FIND v(dout0_17) AT=820.05n

.meas tran vdout0_18ck810 FIND v(dout0_18) AT=820.05n

.meas tran vdout0_19ck810 FIND v(dout0_19) AT=820.05n

.meas tran vdout0_20ck810 FIND v(dout0_20) AT=820.05n

.meas tran vdout0_21ck810 FIND v(dout0_21) AT=820.05n

.meas tran vdout0_22ck810 FIND v(dout0_22) AT=820.05n

.meas tran vdout0_23ck810 FIND v(dout0_23) AT=820.05n

.meas tran vdout0_24ck810 FIND v(dout0_24) AT=820.05n

.meas tran vdout0_25ck810 FIND v(dout0_25) AT=820.05n

.meas tran vdout0_26ck810 FIND v(dout0_26) AT=820.05n

.meas tran vdout0_27ck810 FIND v(dout0_27) AT=820.05n

.meas tran vdout0_28ck810 FIND v(dout0_28) AT=820.05n

.meas tran vdout0_29ck810 FIND v(dout0_29) AT=820.05n

.meas tran vdout0_30ck810 FIND v(dout0_30) AT=820.05n

.meas tran vdout0_31ck810 FIND v(dout0_31) AT=820.05n

.meas tran vdout0_32ck810 FIND v(dout0_32) AT=820.05n

.meas tran vdout0_0ck820 FIND v(dout0_0) AT=830.05n

.meas tran vdout0_1ck820 FIND v(dout0_1) AT=830.05n

.meas tran vdout0_2ck820 FIND v(dout0_2) AT=830.05n

.meas tran vdout0_3ck820 FIND v(dout0_3) AT=830.05n

.meas tran vdout0_4ck820 FIND v(dout0_4) AT=830.05n

.meas tran vdout0_5ck820 FIND v(dout0_5) AT=830.05n

.meas tran vdout0_6ck820 FIND v(dout0_6) AT=830.05n

.meas tran vdout0_7ck820 FIND v(dout0_7) AT=830.05n

.meas tran vdout0_8ck820 FIND v(dout0_8) AT=830.05n

.meas tran vdout0_9ck820 FIND v(dout0_9) AT=830.05n

.meas tran vdout0_10ck820 FIND v(dout0_10) AT=830.05n

.meas tran vdout0_11ck820 FIND v(dout0_11) AT=830.05n

.meas tran vdout0_12ck820 FIND v(dout0_12) AT=830.05n

.meas tran vdout0_13ck820 FIND v(dout0_13) AT=830.05n

.meas tran vdout0_14ck820 FIND v(dout0_14) AT=830.05n

.meas tran vdout0_15ck820 FIND v(dout0_15) AT=830.05n

.meas tran vdout0_16ck820 FIND v(dout0_16) AT=830.05n

.meas tran vdout0_17ck820 FIND v(dout0_17) AT=830.05n

.meas tran vdout0_18ck820 FIND v(dout0_18) AT=830.05n

.meas tran vdout0_19ck820 FIND v(dout0_19) AT=830.05n

.meas tran vdout0_20ck820 FIND v(dout0_20) AT=830.05n

.meas tran vdout0_21ck820 FIND v(dout0_21) AT=830.05n

.meas tran vdout0_22ck820 FIND v(dout0_22) AT=830.05n

.meas tran vdout0_23ck820 FIND v(dout0_23) AT=830.05n

.meas tran vdout0_24ck820 FIND v(dout0_24) AT=830.05n

.meas tran vdout0_25ck820 FIND v(dout0_25) AT=830.05n

.meas tran vdout0_26ck820 FIND v(dout0_26) AT=830.05n

.meas tran vdout0_27ck820 FIND v(dout0_27) AT=830.05n

.meas tran vdout0_28ck820 FIND v(dout0_28) AT=830.05n

.meas tran vdout0_29ck820 FIND v(dout0_29) AT=830.05n

.meas tran vdout0_30ck820 FIND v(dout0_30) AT=830.05n

.meas tran vdout0_31ck820 FIND v(dout0_31) AT=830.05n

.meas tran vdout0_32ck820 FIND v(dout0_32) AT=830.05n

.meas tran vdout0_0ck830 FIND v(dout0_0) AT=840.05n

.meas tran vdout0_1ck830 FIND v(dout0_1) AT=840.05n

.meas tran vdout0_2ck830 FIND v(dout0_2) AT=840.05n

.meas tran vdout0_3ck830 FIND v(dout0_3) AT=840.05n

.meas tran vdout0_4ck830 FIND v(dout0_4) AT=840.05n

.meas tran vdout0_5ck830 FIND v(dout0_5) AT=840.05n

.meas tran vdout0_6ck830 FIND v(dout0_6) AT=840.05n

.meas tran vdout0_7ck830 FIND v(dout0_7) AT=840.05n

.meas tran vdout0_8ck830 FIND v(dout0_8) AT=840.05n

.meas tran vdout0_9ck830 FIND v(dout0_9) AT=840.05n

.meas tran vdout0_10ck830 FIND v(dout0_10) AT=840.05n

.meas tran vdout0_11ck830 FIND v(dout0_11) AT=840.05n

.meas tran vdout0_12ck830 FIND v(dout0_12) AT=840.05n

.meas tran vdout0_13ck830 FIND v(dout0_13) AT=840.05n

.meas tran vdout0_14ck830 FIND v(dout0_14) AT=840.05n

.meas tran vdout0_15ck830 FIND v(dout0_15) AT=840.05n

.meas tran vdout0_16ck830 FIND v(dout0_16) AT=840.05n

.meas tran vdout0_17ck830 FIND v(dout0_17) AT=840.05n

.meas tran vdout0_18ck830 FIND v(dout0_18) AT=840.05n

.meas tran vdout0_19ck830 FIND v(dout0_19) AT=840.05n

.meas tran vdout0_20ck830 FIND v(dout0_20) AT=840.05n

.meas tran vdout0_21ck830 FIND v(dout0_21) AT=840.05n

.meas tran vdout0_22ck830 FIND v(dout0_22) AT=840.05n

.meas tran vdout0_23ck830 FIND v(dout0_23) AT=840.05n

.meas tran vdout0_24ck830 FIND v(dout0_24) AT=840.05n

.meas tran vdout0_25ck830 FIND v(dout0_25) AT=840.05n

.meas tran vdout0_26ck830 FIND v(dout0_26) AT=840.05n

.meas tran vdout0_27ck830 FIND v(dout0_27) AT=840.05n

.meas tran vdout0_28ck830 FIND v(dout0_28) AT=840.05n

.meas tran vdout0_29ck830 FIND v(dout0_29) AT=840.05n

.meas tran vdout0_30ck830 FIND v(dout0_30) AT=840.05n

.meas tran vdout0_31ck830 FIND v(dout0_31) AT=840.05n

.meas tran vdout0_32ck830 FIND v(dout0_32) AT=840.05n

.meas tran vdout0_0ck840 FIND v(dout0_0) AT=850.05n

.meas tran vdout0_1ck840 FIND v(dout0_1) AT=850.05n

.meas tran vdout0_2ck840 FIND v(dout0_2) AT=850.05n

.meas tran vdout0_3ck840 FIND v(dout0_3) AT=850.05n

.meas tran vdout0_4ck840 FIND v(dout0_4) AT=850.05n

.meas tran vdout0_5ck840 FIND v(dout0_5) AT=850.05n

.meas tran vdout0_6ck840 FIND v(dout0_6) AT=850.05n

.meas tran vdout0_7ck840 FIND v(dout0_7) AT=850.05n

.meas tran vdout0_8ck840 FIND v(dout0_8) AT=850.05n

.meas tran vdout0_9ck840 FIND v(dout0_9) AT=850.05n

.meas tran vdout0_10ck840 FIND v(dout0_10) AT=850.05n

.meas tran vdout0_11ck840 FIND v(dout0_11) AT=850.05n

.meas tran vdout0_12ck840 FIND v(dout0_12) AT=850.05n

.meas tran vdout0_13ck840 FIND v(dout0_13) AT=850.05n

.meas tran vdout0_14ck840 FIND v(dout0_14) AT=850.05n

.meas tran vdout0_15ck840 FIND v(dout0_15) AT=850.05n

.meas tran vdout0_16ck840 FIND v(dout0_16) AT=850.05n

.meas tran vdout0_17ck840 FIND v(dout0_17) AT=850.05n

.meas tran vdout0_18ck840 FIND v(dout0_18) AT=850.05n

.meas tran vdout0_19ck840 FIND v(dout0_19) AT=850.05n

.meas tran vdout0_20ck840 FIND v(dout0_20) AT=850.05n

.meas tran vdout0_21ck840 FIND v(dout0_21) AT=850.05n

.meas tran vdout0_22ck840 FIND v(dout0_22) AT=850.05n

.meas tran vdout0_23ck840 FIND v(dout0_23) AT=850.05n

.meas tran vdout0_24ck840 FIND v(dout0_24) AT=850.05n

.meas tran vdout0_25ck840 FIND v(dout0_25) AT=850.05n

.meas tran vdout0_26ck840 FIND v(dout0_26) AT=850.05n

.meas tran vdout0_27ck840 FIND v(dout0_27) AT=850.05n

.meas tran vdout0_28ck840 FIND v(dout0_28) AT=850.05n

.meas tran vdout0_29ck840 FIND v(dout0_29) AT=850.05n

.meas tran vdout0_30ck840 FIND v(dout0_30) AT=850.05n

.meas tran vdout0_31ck840 FIND v(dout0_31) AT=850.05n

.meas tran vdout0_32ck840 FIND v(dout0_32) AT=850.05n

.meas tran vdout0_0ck870 FIND v(dout0_0) AT=880.05n

.meas tran vdout0_1ck870 FIND v(dout0_1) AT=880.05n

.meas tran vdout0_2ck870 FIND v(dout0_2) AT=880.05n

.meas tran vdout0_3ck870 FIND v(dout0_3) AT=880.05n

.meas tran vdout0_4ck870 FIND v(dout0_4) AT=880.05n

.meas tran vdout0_5ck870 FIND v(dout0_5) AT=880.05n

.meas tran vdout0_6ck870 FIND v(dout0_6) AT=880.05n

.meas tran vdout0_7ck870 FIND v(dout0_7) AT=880.05n

.meas tran vdout0_8ck870 FIND v(dout0_8) AT=880.05n

.meas tran vdout0_9ck870 FIND v(dout0_9) AT=880.05n

.meas tran vdout0_10ck870 FIND v(dout0_10) AT=880.05n

.meas tran vdout0_11ck870 FIND v(dout0_11) AT=880.05n

.meas tran vdout0_12ck870 FIND v(dout0_12) AT=880.05n

.meas tran vdout0_13ck870 FIND v(dout0_13) AT=880.05n

.meas tran vdout0_14ck870 FIND v(dout0_14) AT=880.05n

.meas tran vdout0_15ck870 FIND v(dout0_15) AT=880.05n

.meas tran vdout0_16ck870 FIND v(dout0_16) AT=880.05n

.meas tran vdout0_17ck870 FIND v(dout0_17) AT=880.05n

.meas tran vdout0_18ck870 FIND v(dout0_18) AT=880.05n

.meas tran vdout0_19ck870 FIND v(dout0_19) AT=880.05n

.meas tran vdout0_20ck870 FIND v(dout0_20) AT=880.05n

.meas tran vdout0_21ck870 FIND v(dout0_21) AT=880.05n

.meas tran vdout0_22ck870 FIND v(dout0_22) AT=880.05n

.meas tran vdout0_23ck870 FIND v(dout0_23) AT=880.05n

.meas tran vdout0_24ck870 FIND v(dout0_24) AT=880.05n

.meas tran vdout0_25ck870 FIND v(dout0_25) AT=880.05n

.meas tran vdout0_26ck870 FIND v(dout0_26) AT=880.05n

.meas tran vdout0_27ck870 FIND v(dout0_27) AT=880.05n

.meas tran vdout0_28ck870 FIND v(dout0_28) AT=880.05n

.meas tran vdout0_29ck870 FIND v(dout0_29) AT=880.05n

.meas tran vdout0_30ck870 FIND v(dout0_30) AT=880.05n

.meas tran vdout0_31ck870 FIND v(dout0_31) AT=880.05n

.meas tran vdout0_32ck870 FIND v(dout0_32) AT=880.05n

.meas tran vdout0_0ck890 FIND v(dout0_0) AT=900.05n

.meas tran vdout0_1ck890 FIND v(dout0_1) AT=900.05n

.meas tran vdout0_2ck890 FIND v(dout0_2) AT=900.05n

.meas tran vdout0_3ck890 FIND v(dout0_3) AT=900.05n

.meas tran vdout0_4ck890 FIND v(dout0_4) AT=900.05n

.meas tran vdout0_5ck890 FIND v(dout0_5) AT=900.05n

.meas tran vdout0_6ck890 FIND v(dout0_6) AT=900.05n

.meas tran vdout0_7ck890 FIND v(dout0_7) AT=900.05n

.meas tran vdout0_8ck890 FIND v(dout0_8) AT=900.05n

.meas tran vdout0_9ck890 FIND v(dout0_9) AT=900.05n

.meas tran vdout0_10ck890 FIND v(dout0_10) AT=900.05n

.meas tran vdout0_11ck890 FIND v(dout0_11) AT=900.05n

.meas tran vdout0_12ck890 FIND v(dout0_12) AT=900.05n

.meas tran vdout0_13ck890 FIND v(dout0_13) AT=900.05n

.meas tran vdout0_14ck890 FIND v(dout0_14) AT=900.05n

.meas tran vdout0_15ck890 FIND v(dout0_15) AT=900.05n

.meas tran vdout0_16ck890 FIND v(dout0_16) AT=900.05n

.meas tran vdout0_17ck890 FIND v(dout0_17) AT=900.05n

.meas tran vdout0_18ck890 FIND v(dout0_18) AT=900.05n

.meas tran vdout0_19ck890 FIND v(dout0_19) AT=900.05n

.meas tran vdout0_20ck890 FIND v(dout0_20) AT=900.05n

.meas tran vdout0_21ck890 FIND v(dout0_21) AT=900.05n

.meas tran vdout0_22ck890 FIND v(dout0_22) AT=900.05n

.meas tran vdout0_23ck890 FIND v(dout0_23) AT=900.05n

.meas tran vdout0_24ck890 FIND v(dout0_24) AT=900.05n

.meas tran vdout0_25ck890 FIND v(dout0_25) AT=900.05n

.meas tran vdout0_26ck890 FIND v(dout0_26) AT=900.05n

.meas tran vdout0_27ck890 FIND v(dout0_27) AT=900.05n

.meas tran vdout0_28ck890 FIND v(dout0_28) AT=900.05n

.meas tran vdout0_29ck890 FIND v(dout0_29) AT=900.05n

.meas tran vdout0_30ck890 FIND v(dout0_30) AT=900.05n

.meas tran vdout0_31ck890 FIND v(dout0_31) AT=900.05n

.meas tran vdout0_32ck890 FIND v(dout0_32) AT=900.05n

.meas tran vdout0_0ck900 FIND v(dout0_0) AT=910.05n

.meas tran vdout0_1ck900 FIND v(dout0_1) AT=910.05n

.meas tran vdout0_2ck900 FIND v(dout0_2) AT=910.05n

.meas tran vdout0_3ck900 FIND v(dout0_3) AT=910.05n

.meas tran vdout0_4ck900 FIND v(dout0_4) AT=910.05n

.meas tran vdout0_5ck900 FIND v(dout0_5) AT=910.05n

.meas tran vdout0_6ck900 FIND v(dout0_6) AT=910.05n

.meas tran vdout0_7ck900 FIND v(dout0_7) AT=910.05n

.meas tran vdout0_8ck900 FIND v(dout0_8) AT=910.05n

.meas tran vdout0_9ck900 FIND v(dout0_9) AT=910.05n

.meas tran vdout0_10ck900 FIND v(dout0_10) AT=910.05n

.meas tran vdout0_11ck900 FIND v(dout0_11) AT=910.05n

.meas tran vdout0_12ck900 FIND v(dout0_12) AT=910.05n

.meas tran vdout0_13ck900 FIND v(dout0_13) AT=910.05n

.meas tran vdout0_14ck900 FIND v(dout0_14) AT=910.05n

.meas tran vdout0_15ck900 FIND v(dout0_15) AT=910.05n

.meas tran vdout0_16ck900 FIND v(dout0_16) AT=910.05n

.meas tran vdout0_17ck900 FIND v(dout0_17) AT=910.05n

.meas tran vdout0_18ck900 FIND v(dout0_18) AT=910.05n

.meas tran vdout0_19ck900 FIND v(dout0_19) AT=910.05n

.meas tran vdout0_20ck900 FIND v(dout0_20) AT=910.05n

.meas tran vdout0_21ck900 FIND v(dout0_21) AT=910.05n

.meas tran vdout0_22ck900 FIND v(dout0_22) AT=910.05n

.meas tran vdout0_23ck900 FIND v(dout0_23) AT=910.05n

.meas tran vdout0_24ck900 FIND v(dout0_24) AT=910.05n

.meas tran vdout0_25ck900 FIND v(dout0_25) AT=910.05n

.meas tran vdout0_26ck900 FIND v(dout0_26) AT=910.05n

.meas tran vdout0_27ck900 FIND v(dout0_27) AT=910.05n

.meas tran vdout0_28ck900 FIND v(dout0_28) AT=910.05n

.meas tran vdout0_29ck900 FIND v(dout0_29) AT=910.05n

.meas tran vdout0_30ck900 FIND v(dout0_30) AT=910.05n

.meas tran vdout0_31ck900 FIND v(dout0_31) AT=910.05n

.meas tran vdout0_32ck900 FIND v(dout0_32) AT=910.05n

.meas tran vdout0_0ck910 FIND v(dout0_0) AT=920.05n

.meas tran vdout0_1ck910 FIND v(dout0_1) AT=920.05n

.meas tran vdout0_2ck910 FIND v(dout0_2) AT=920.05n

.meas tran vdout0_3ck910 FIND v(dout0_3) AT=920.05n

.meas tran vdout0_4ck910 FIND v(dout0_4) AT=920.05n

.meas tran vdout0_5ck910 FIND v(dout0_5) AT=920.05n

.meas tran vdout0_6ck910 FIND v(dout0_6) AT=920.05n

.meas tran vdout0_7ck910 FIND v(dout0_7) AT=920.05n

.meas tran vdout0_8ck910 FIND v(dout0_8) AT=920.05n

.meas tran vdout0_9ck910 FIND v(dout0_9) AT=920.05n

.meas tran vdout0_10ck910 FIND v(dout0_10) AT=920.05n

.meas tran vdout0_11ck910 FIND v(dout0_11) AT=920.05n

.meas tran vdout0_12ck910 FIND v(dout0_12) AT=920.05n

.meas tran vdout0_13ck910 FIND v(dout0_13) AT=920.05n

.meas tran vdout0_14ck910 FIND v(dout0_14) AT=920.05n

.meas tran vdout0_15ck910 FIND v(dout0_15) AT=920.05n

.meas tran vdout0_16ck910 FIND v(dout0_16) AT=920.05n

.meas tran vdout0_17ck910 FIND v(dout0_17) AT=920.05n

.meas tran vdout0_18ck910 FIND v(dout0_18) AT=920.05n

.meas tran vdout0_19ck910 FIND v(dout0_19) AT=920.05n

.meas tran vdout0_20ck910 FIND v(dout0_20) AT=920.05n

.meas tran vdout0_21ck910 FIND v(dout0_21) AT=920.05n

.meas tran vdout0_22ck910 FIND v(dout0_22) AT=920.05n

.meas tran vdout0_23ck910 FIND v(dout0_23) AT=920.05n

.meas tran vdout0_24ck910 FIND v(dout0_24) AT=920.05n

.meas tran vdout0_25ck910 FIND v(dout0_25) AT=920.05n

.meas tran vdout0_26ck910 FIND v(dout0_26) AT=920.05n

.meas tran vdout0_27ck910 FIND v(dout0_27) AT=920.05n

.meas tran vdout0_28ck910 FIND v(dout0_28) AT=920.05n

.meas tran vdout0_29ck910 FIND v(dout0_29) AT=920.05n

.meas tran vdout0_30ck910 FIND v(dout0_30) AT=920.05n

.meas tran vdout0_31ck910 FIND v(dout0_31) AT=920.05n

.meas tran vdout0_32ck910 FIND v(dout0_32) AT=920.05n

.meas tran vdout0_0ck920 FIND v(dout0_0) AT=930.05n

.meas tran vdout0_1ck920 FIND v(dout0_1) AT=930.05n

.meas tran vdout0_2ck920 FIND v(dout0_2) AT=930.05n

.meas tran vdout0_3ck920 FIND v(dout0_3) AT=930.05n

.meas tran vdout0_4ck920 FIND v(dout0_4) AT=930.05n

.meas tran vdout0_5ck920 FIND v(dout0_5) AT=930.05n

.meas tran vdout0_6ck920 FIND v(dout0_6) AT=930.05n

.meas tran vdout0_7ck920 FIND v(dout0_7) AT=930.05n

.meas tran vdout0_8ck920 FIND v(dout0_8) AT=930.05n

.meas tran vdout0_9ck920 FIND v(dout0_9) AT=930.05n

.meas tran vdout0_10ck920 FIND v(dout0_10) AT=930.05n

.meas tran vdout0_11ck920 FIND v(dout0_11) AT=930.05n

.meas tran vdout0_12ck920 FIND v(dout0_12) AT=930.05n

.meas tran vdout0_13ck920 FIND v(dout0_13) AT=930.05n

.meas tran vdout0_14ck920 FIND v(dout0_14) AT=930.05n

.meas tran vdout0_15ck920 FIND v(dout0_15) AT=930.05n

.meas tran vdout0_16ck920 FIND v(dout0_16) AT=930.05n

.meas tran vdout0_17ck920 FIND v(dout0_17) AT=930.05n

.meas tran vdout0_18ck920 FIND v(dout0_18) AT=930.05n

.meas tran vdout0_19ck920 FIND v(dout0_19) AT=930.05n

.meas tran vdout0_20ck920 FIND v(dout0_20) AT=930.05n

.meas tran vdout0_21ck920 FIND v(dout0_21) AT=930.05n

.meas tran vdout0_22ck920 FIND v(dout0_22) AT=930.05n

.meas tran vdout0_23ck920 FIND v(dout0_23) AT=930.05n

.meas tran vdout0_24ck920 FIND v(dout0_24) AT=930.05n

.meas tran vdout0_25ck920 FIND v(dout0_25) AT=930.05n

.meas tran vdout0_26ck920 FIND v(dout0_26) AT=930.05n

.meas tran vdout0_27ck920 FIND v(dout0_27) AT=930.05n

.meas tran vdout0_28ck920 FIND v(dout0_28) AT=930.05n

.meas tran vdout0_29ck920 FIND v(dout0_29) AT=930.05n

.meas tran vdout0_30ck920 FIND v(dout0_30) AT=930.05n

.meas tran vdout0_31ck920 FIND v(dout0_31) AT=930.05n

.meas tran vdout0_32ck920 FIND v(dout0_32) AT=930.05n

.meas tran vdout0_0ck930 FIND v(dout0_0) AT=940.05n

.meas tran vdout0_1ck930 FIND v(dout0_1) AT=940.05n

.meas tran vdout0_2ck930 FIND v(dout0_2) AT=940.05n

.meas tran vdout0_3ck930 FIND v(dout0_3) AT=940.05n

.meas tran vdout0_4ck930 FIND v(dout0_4) AT=940.05n

.meas tran vdout0_5ck930 FIND v(dout0_5) AT=940.05n

.meas tran vdout0_6ck930 FIND v(dout0_6) AT=940.05n

.meas tran vdout0_7ck930 FIND v(dout0_7) AT=940.05n

.meas tran vdout0_8ck930 FIND v(dout0_8) AT=940.05n

.meas tran vdout0_9ck930 FIND v(dout0_9) AT=940.05n

.meas tran vdout0_10ck930 FIND v(dout0_10) AT=940.05n

.meas tran vdout0_11ck930 FIND v(dout0_11) AT=940.05n

.meas tran vdout0_12ck930 FIND v(dout0_12) AT=940.05n

.meas tran vdout0_13ck930 FIND v(dout0_13) AT=940.05n

.meas tran vdout0_14ck930 FIND v(dout0_14) AT=940.05n

.meas tran vdout0_15ck930 FIND v(dout0_15) AT=940.05n

.meas tran vdout0_16ck930 FIND v(dout0_16) AT=940.05n

.meas tran vdout0_17ck930 FIND v(dout0_17) AT=940.05n

.meas tran vdout0_18ck930 FIND v(dout0_18) AT=940.05n

.meas tran vdout0_19ck930 FIND v(dout0_19) AT=940.05n

.meas tran vdout0_20ck930 FIND v(dout0_20) AT=940.05n

.meas tran vdout0_21ck930 FIND v(dout0_21) AT=940.05n

.meas tran vdout0_22ck930 FIND v(dout0_22) AT=940.05n

.meas tran vdout0_23ck930 FIND v(dout0_23) AT=940.05n

.meas tran vdout0_24ck930 FIND v(dout0_24) AT=940.05n

.meas tran vdout0_25ck930 FIND v(dout0_25) AT=940.05n

.meas tran vdout0_26ck930 FIND v(dout0_26) AT=940.05n

.meas tran vdout0_27ck930 FIND v(dout0_27) AT=940.05n

.meas tran vdout0_28ck930 FIND v(dout0_28) AT=940.05n

.meas tran vdout0_29ck930 FIND v(dout0_29) AT=940.05n

.meas tran vdout0_30ck930 FIND v(dout0_30) AT=940.05n

.meas tran vdout0_31ck930 FIND v(dout0_31) AT=940.05n

.meas tran vdout0_32ck930 FIND v(dout0_32) AT=940.05n

.meas tran vdout0_0ck950 FIND v(dout0_0) AT=960.05n

.meas tran vdout0_1ck950 FIND v(dout0_1) AT=960.05n

.meas tran vdout0_2ck950 FIND v(dout0_2) AT=960.05n

.meas tran vdout0_3ck950 FIND v(dout0_3) AT=960.05n

.meas tran vdout0_4ck950 FIND v(dout0_4) AT=960.05n

.meas tran vdout0_5ck950 FIND v(dout0_5) AT=960.05n

.meas tran vdout0_6ck950 FIND v(dout0_6) AT=960.05n

.meas tran vdout0_7ck950 FIND v(dout0_7) AT=960.05n

.meas tran vdout0_8ck950 FIND v(dout0_8) AT=960.05n

.meas tran vdout0_9ck950 FIND v(dout0_9) AT=960.05n

.meas tran vdout0_10ck950 FIND v(dout0_10) AT=960.05n

.meas tran vdout0_11ck950 FIND v(dout0_11) AT=960.05n

.meas tran vdout0_12ck950 FIND v(dout0_12) AT=960.05n

.meas tran vdout0_13ck950 FIND v(dout0_13) AT=960.05n

.meas tran vdout0_14ck950 FIND v(dout0_14) AT=960.05n

.meas tran vdout0_15ck950 FIND v(dout0_15) AT=960.05n

.meas tran vdout0_16ck950 FIND v(dout0_16) AT=960.05n

.meas tran vdout0_17ck950 FIND v(dout0_17) AT=960.05n

.meas tran vdout0_18ck950 FIND v(dout0_18) AT=960.05n

.meas tran vdout0_19ck950 FIND v(dout0_19) AT=960.05n

.meas tran vdout0_20ck950 FIND v(dout0_20) AT=960.05n

.meas tran vdout0_21ck950 FIND v(dout0_21) AT=960.05n

.meas tran vdout0_22ck950 FIND v(dout0_22) AT=960.05n

.meas tran vdout0_23ck950 FIND v(dout0_23) AT=960.05n

.meas tran vdout0_24ck950 FIND v(dout0_24) AT=960.05n

.meas tran vdout0_25ck950 FIND v(dout0_25) AT=960.05n

.meas tran vdout0_26ck950 FIND v(dout0_26) AT=960.05n

.meas tran vdout0_27ck950 FIND v(dout0_27) AT=960.05n

.meas tran vdout0_28ck950 FIND v(dout0_28) AT=960.05n

.meas tran vdout0_29ck950 FIND v(dout0_29) AT=960.05n

.meas tran vdout0_30ck950 FIND v(dout0_30) AT=960.05n

.meas tran vdout0_31ck950 FIND v(dout0_31) AT=960.05n

.meas tran vdout0_32ck950 FIND v(dout0_32) AT=960.05n

.meas tran vdout0_0ck1020 FIND v(dout0_0) AT=1030.05n

.meas tran vdout0_1ck1020 FIND v(dout0_1) AT=1030.05n

.meas tran vdout0_2ck1020 FIND v(dout0_2) AT=1030.05n

.meas tran vdout0_3ck1020 FIND v(dout0_3) AT=1030.05n

.meas tran vdout0_4ck1020 FIND v(dout0_4) AT=1030.05n

.meas tran vdout0_5ck1020 FIND v(dout0_5) AT=1030.05n

.meas tran vdout0_6ck1020 FIND v(dout0_6) AT=1030.05n

.meas tran vdout0_7ck1020 FIND v(dout0_7) AT=1030.05n

.meas tran vdout0_8ck1020 FIND v(dout0_8) AT=1030.05n

.meas tran vdout0_9ck1020 FIND v(dout0_9) AT=1030.05n

.meas tran vdout0_10ck1020 FIND v(dout0_10) AT=1030.05n

.meas tran vdout0_11ck1020 FIND v(dout0_11) AT=1030.05n

.meas tran vdout0_12ck1020 FIND v(dout0_12) AT=1030.05n

.meas tran vdout0_13ck1020 FIND v(dout0_13) AT=1030.05n

.meas tran vdout0_14ck1020 FIND v(dout0_14) AT=1030.05n

.meas tran vdout0_15ck1020 FIND v(dout0_15) AT=1030.05n

.meas tran vdout0_16ck1020 FIND v(dout0_16) AT=1030.05n

.meas tran vdout0_17ck1020 FIND v(dout0_17) AT=1030.05n

.meas tran vdout0_18ck1020 FIND v(dout0_18) AT=1030.05n

.meas tran vdout0_19ck1020 FIND v(dout0_19) AT=1030.05n

.meas tran vdout0_20ck1020 FIND v(dout0_20) AT=1030.05n

.meas tran vdout0_21ck1020 FIND v(dout0_21) AT=1030.05n

.meas tran vdout0_22ck1020 FIND v(dout0_22) AT=1030.05n

.meas tran vdout0_23ck1020 FIND v(dout0_23) AT=1030.05n

.meas tran vdout0_24ck1020 FIND v(dout0_24) AT=1030.05n

.meas tran vdout0_25ck1020 FIND v(dout0_25) AT=1030.05n

.meas tran vdout0_26ck1020 FIND v(dout0_26) AT=1030.05n

.meas tran vdout0_27ck1020 FIND v(dout0_27) AT=1030.05n

.meas tran vdout0_28ck1020 FIND v(dout0_28) AT=1030.05n

.meas tran vdout0_29ck1020 FIND v(dout0_29) AT=1030.05n

.meas tran vdout0_30ck1020 FIND v(dout0_30) AT=1030.05n

.meas tran vdout0_31ck1020 FIND v(dout0_31) AT=1030.05n

.meas tran vdout0_32ck1020 FIND v(dout0_32) AT=1030.05n

.meas tran vdout0_0ck1040 FIND v(dout0_0) AT=1050.05n

.meas tran vdout0_1ck1040 FIND v(dout0_1) AT=1050.05n

.meas tran vdout0_2ck1040 FIND v(dout0_2) AT=1050.05n

.meas tran vdout0_3ck1040 FIND v(dout0_3) AT=1050.05n

.meas tran vdout0_4ck1040 FIND v(dout0_4) AT=1050.05n

.meas tran vdout0_5ck1040 FIND v(dout0_5) AT=1050.05n

.meas tran vdout0_6ck1040 FIND v(dout0_6) AT=1050.05n

.meas tran vdout0_7ck1040 FIND v(dout0_7) AT=1050.05n

.meas tran vdout0_8ck1040 FIND v(dout0_8) AT=1050.05n

.meas tran vdout0_9ck1040 FIND v(dout0_9) AT=1050.05n

.meas tran vdout0_10ck1040 FIND v(dout0_10) AT=1050.05n

.meas tran vdout0_11ck1040 FIND v(dout0_11) AT=1050.05n

.meas tran vdout0_12ck1040 FIND v(dout0_12) AT=1050.05n

.meas tran vdout0_13ck1040 FIND v(dout0_13) AT=1050.05n

.meas tran vdout0_14ck1040 FIND v(dout0_14) AT=1050.05n

.meas tran vdout0_15ck1040 FIND v(dout0_15) AT=1050.05n

.meas tran vdout0_16ck1040 FIND v(dout0_16) AT=1050.05n

.meas tran vdout0_17ck1040 FIND v(dout0_17) AT=1050.05n

.meas tran vdout0_18ck1040 FIND v(dout0_18) AT=1050.05n

.meas tran vdout0_19ck1040 FIND v(dout0_19) AT=1050.05n

.meas tran vdout0_20ck1040 FIND v(dout0_20) AT=1050.05n

.meas tran vdout0_21ck1040 FIND v(dout0_21) AT=1050.05n

.meas tran vdout0_22ck1040 FIND v(dout0_22) AT=1050.05n

.meas tran vdout0_23ck1040 FIND v(dout0_23) AT=1050.05n

.meas tran vdout0_24ck1040 FIND v(dout0_24) AT=1050.05n

.meas tran vdout0_25ck1040 FIND v(dout0_25) AT=1050.05n

.meas tran vdout0_26ck1040 FIND v(dout0_26) AT=1050.05n

.meas tran vdout0_27ck1040 FIND v(dout0_27) AT=1050.05n

.meas tran vdout0_28ck1040 FIND v(dout0_28) AT=1050.05n

.meas tran vdout0_29ck1040 FIND v(dout0_29) AT=1050.05n

.meas tran vdout0_30ck1040 FIND v(dout0_30) AT=1050.05n

.meas tran vdout0_31ck1040 FIND v(dout0_31) AT=1050.05n

.meas tran vdout0_32ck1040 FIND v(dout0_32) AT=1050.05n

.meas tran vdout0_0ck1080 FIND v(dout0_0) AT=1090.05n

.meas tran vdout0_1ck1080 FIND v(dout0_1) AT=1090.05n

.meas tran vdout0_2ck1080 FIND v(dout0_2) AT=1090.05n

.meas tran vdout0_3ck1080 FIND v(dout0_3) AT=1090.05n

.meas tran vdout0_4ck1080 FIND v(dout0_4) AT=1090.05n

.meas tran vdout0_5ck1080 FIND v(dout0_5) AT=1090.05n

.meas tran vdout0_6ck1080 FIND v(dout0_6) AT=1090.05n

.meas tran vdout0_7ck1080 FIND v(dout0_7) AT=1090.05n

.meas tran vdout0_8ck1080 FIND v(dout0_8) AT=1090.05n

.meas tran vdout0_9ck1080 FIND v(dout0_9) AT=1090.05n

.meas tran vdout0_10ck1080 FIND v(dout0_10) AT=1090.05n

.meas tran vdout0_11ck1080 FIND v(dout0_11) AT=1090.05n

.meas tran vdout0_12ck1080 FIND v(dout0_12) AT=1090.05n

.meas tran vdout0_13ck1080 FIND v(dout0_13) AT=1090.05n

.meas tran vdout0_14ck1080 FIND v(dout0_14) AT=1090.05n

.meas tran vdout0_15ck1080 FIND v(dout0_15) AT=1090.05n

.meas tran vdout0_16ck1080 FIND v(dout0_16) AT=1090.05n

.meas tran vdout0_17ck1080 FIND v(dout0_17) AT=1090.05n

.meas tran vdout0_18ck1080 FIND v(dout0_18) AT=1090.05n

.meas tran vdout0_19ck1080 FIND v(dout0_19) AT=1090.05n

.meas tran vdout0_20ck1080 FIND v(dout0_20) AT=1090.05n

.meas tran vdout0_21ck1080 FIND v(dout0_21) AT=1090.05n

.meas tran vdout0_22ck1080 FIND v(dout0_22) AT=1090.05n

.meas tran vdout0_23ck1080 FIND v(dout0_23) AT=1090.05n

.meas tran vdout0_24ck1080 FIND v(dout0_24) AT=1090.05n

.meas tran vdout0_25ck1080 FIND v(dout0_25) AT=1090.05n

.meas tran vdout0_26ck1080 FIND v(dout0_26) AT=1090.05n

.meas tran vdout0_27ck1080 FIND v(dout0_27) AT=1090.05n

.meas tran vdout0_28ck1080 FIND v(dout0_28) AT=1090.05n

.meas tran vdout0_29ck1080 FIND v(dout0_29) AT=1090.05n

.meas tran vdout0_30ck1080 FIND v(dout0_30) AT=1090.05n

.meas tran vdout0_31ck1080 FIND v(dout0_31) AT=1090.05n

.meas tran vdout0_32ck1080 FIND v(dout0_32) AT=1090.05n

.meas tran vdout0_0ck1150 FIND v(dout0_0) AT=1160.05n

.meas tran vdout0_1ck1150 FIND v(dout0_1) AT=1160.05n

.meas tran vdout0_2ck1150 FIND v(dout0_2) AT=1160.05n

.meas tran vdout0_3ck1150 FIND v(dout0_3) AT=1160.05n

.meas tran vdout0_4ck1150 FIND v(dout0_4) AT=1160.05n

.meas tran vdout0_5ck1150 FIND v(dout0_5) AT=1160.05n

.meas tran vdout0_6ck1150 FIND v(dout0_6) AT=1160.05n

.meas tran vdout0_7ck1150 FIND v(dout0_7) AT=1160.05n

.meas tran vdout0_8ck1150 FIND v(dout0_8) AT=1160.05n

.meas tran vdout0_9ck1150 FIND v(dout0_9) AT=1160.05n

.meas tran vdout0_10ck1150 FIND v(dout0_10) AT=1160.05n

.meas tran vdout0_11ck1150 FIND v(dout0_11) AT=1160.05n

.meas tran vdout0_12ck1150 FIND v(dout0_12) AT=1160.05n

.meas tran vdout0_13ck1150 FIND v(dout0_13) AT=1160.05n

.meas tran vdout0_14ck1150 FIND v(dout0_14) AT=1160.05n

.meas tran vdout0_15ck1150 FIND v(dout0_15) AT=1160.05n

.meas tran vdout0_16ck1150 FIND v(dout0_16) AT=1160.05n

.meas tran vdout0_17ck1150 FIND v(dout0_17) AT=1160.05n

.meas tran vdout0_18ck1150 FIND v(dout0_18) AT=1160.05n

.meas tran vdout0_19ck1150 FIND v(dout0_19) AT=1160.05n

.meas tran vdout0_20ck1150 FIND v(dout0_20) AT=1160.05n

.meas tran vdout0_21ck1150 FIND v(dout0_21) AT=1160.05n

.meas tran vdout0_22ck1150 FIND v(dout0_22) AT=1160.05n

.meas tran vdout0_23ck1150 FIND v(dout0_23) AT=1160.05n

.meas tran vdout0_24ck1150 FIND v(dout0_24) AT=1160.05n

.meas tran vdout0_25ck1150 FIND v(dout0_25) AT=1160.05n

.meas tran vdout0_26ck1150 FIND v(dout0_26) AT=1160.05n

.meas tran vdout0_27ck1150 FIND v(dout0_27) AT=1160.05n

.meas tran vdout0_28ck1150 FIND v(dout0_28) AT=1160.05n

.meas tran vdout0_29ck1150 FIND v(dout0_29) AT=1160.05n

.meas tran vdout0_30ck1150 FIND v(dout0_30) AT=1160.05n

.meas tran vdout0_31ck1150 FIND v(dout0_31) AT=1160.05n

.meas tran vdout0_32ck1150 FIND v(dout0_32) AT=1160.05n

.meas tran vdout0_0ck1190 FIND v(dout0_0) AT=1200.05n

.meas tran vdout0_1ck1190 FIND v(dout0_1) AT=1200.05n

.meas tran vdout0_2ck1190 FIND v(dout0_2) AT=1200.05n

.meas tran vdout0_3ck1190 FIND v(dout0_3) AT=1200.05n

.meas tran vdout0_4ck1190 FIND v(dout0_4) AT=1200.05n

.meas tran vdout0_5ck1190 FIND v(dout0_5) AT=1200.05n

.meas tran vdout0_6ck1190 FIND v(dout0_6) AT=1200.05n

.meas tran vdout0_7ck1190 FIND v(dout0_7) AT=1200.05n

.meas tran vdout0_8ck1190 FIND v(dout0_8) AT=1200.05n

.meas tran vdout0_9ck1190 FIND v(dout0_9) AT=1200.05n

.meas tran vdout0_10ck1190 FIND v(dout0_10) AT=1200.05n

.meas tran vdout0_11ck1190 FIND v(dout0_11) AT=1200.05n

.meas tran vdout0_12ck1190 FIND v(dout0_12) AT=1200.05n

.meas tran vdout0_13ck1190 FIND v(dout0_13) AT=1200.05n

.meas tran vdout0_14ck1190 FIND v(dout0_14) AT=1200.05n

.meas tran vdout0_15ck1190 FIND v(dout0_15) AT=1200.05n

.meas tran vdout0_16ck1190 FIND v(dout0_16) AT=1200.05n

.meas tran vdout0_17ck1190 FIND v(dout0_17) AT=1200.05n

.meas tran vdout0_18ck1190 FIND v(dout0_18) AT=1200.05n

.meas tran vdout0_19ck1190 FIND v(dout0_19) AT=1200.05n

.meas tran vdout0_20ck1190 FIND v(dout0_20) AT=1200.05n

.meas tran vdout0_21ck1190 FIND v(dout0_21) AT=1200.05n

.meas tran vdout0_22ck1190 FIND v(dout0_22) AT=1200.05n

.meas tran vdout0_23ck1190 FIND v(dout0_23) AT=1200.05n

.meas tran vdout0_24ck1190 FIND v(dout0_24) AT=1200.05n

.meas tran vdout0_25ck1190 FIND v(dout0_25) AT=1200.05n

.meas tran vdout0_26ck1190 FIND v(dout0_26) AT=1200.05n

.meas tran vdout0_27ck1190 FIND v(dout0_27) AT=1200.05n

.meas tran vdout0_28ck1190 FIND v(dout0_28) AT=1200.05n

.meas tran vdout0_29ck1190 FIND v(dout0_29) AT=1200.05n

.meas tran vdout0_30ck1190 FIND v(dout0_30) AT=1200.05n

.meas tran vdout0_31ck1190 FIND v(dout0_31) AT=1200.05n

.meas tran vdout0_32ck1190 FIND v(dout0_32) AT=1200.05n

.meas tran vdout0_0ck1200 FIND v(dout0_0) AT=1210.05n

.meas tran vdout0_1ck1200 FIND v(dout0_1) AT=1210.05n

.meas tran vdout0_2ck1200 FIND v(dout0_2) AT=1210.05n

.meas tran vdout0_3ck1200 FIND v(dout0_3) AT=1210.05n

.meas tran vdout0_4ck1200 FIND v(dout0_4) AT=1210.05n

.meas tran vdout0_5ck1200 FIND v(dout0_5) AT=1210.05n

.meas tran vdout0_6ck1200 FIND v(dout0_6) AT=1210.05n

.meas tran vdout0_7ck1200 FIND v(dout0_7) AT=1210.05n

.meas tran vdout0_8ck1200 FIND v(dout0_8) AT=1210.05n

.meas tran vdout0_9ck1200 FIND v(dout0_9) AT=1210.05n

.meas tran vdout0_10ck1200 FIND v(dout0_10) AT=1210.05n

.meas tran vdout0_11ck1200 FIND v(dout0_11) AT=1210.05n

.meas tran vdout0_12ck1200 FIND v(dout0_12) AT=1210.05n

.meas tran vdout0_13ck1200 FIND v(dout0_13) AT=1210.05n

.meas tran vdout0_14ck1200 FIND v(dout0_14) AT=1210.05n

.meas tran vdout0_15ck1200 FIND v(dout0_15) AT=1210.05n

.meas tran vdout0_16ck1200 FIND v(dout0_16) AT=1210.05n

.meas tran vdout0_17ck1200 FIND v(dout0_17) AT=1210.05n

.meas tran vdout0_18ck1200 FIND v(dout0_18) AT=1210.05n

.meas tran vdout0_19ck1200 FIND v(dout0_19) AT=1210.05n

.meas tran vdout0_20ck1200 FIND v(dout0_20) AT=1210.05n

.meas tran vdout0_21ck1200 FIND v(dout0_21) AT=1210.05n

.meas tran vdout0_22ck1200 FIND v(dout0_22) AT=1210.05n

.meas tran vdout0_23ck1200 FIND v(dout0_23) AT=1210.05n

.meas tran vdout0_24ck1200 FIND v(dout0_24) AT=1210.05n

.meas tran vdout0_25ck1200 FIND v(dout0_25) AT=1210.05n

.meas tran vdout0_26ck1200 FIND v(dout0_26) AT=1210.05n

.meas tran vdout0_27ck1200 FIND v(dout0_27) AT=1210.05n

.meas tran vdout0_28ck1200 FIND v(dout0_28) AT=1210.05n

.meas tran vdout0_29ck1200 FIND v(dout0_29) AT=1210.05n

.meas tran vdout0_30ck1200 FIND v(dout0_30) AT=1210.05n

.meas tran vdout0_31ck1200 FIND v(dout0_31) AT=1210.05n

.meas tran vdout0_32ck1200 FIND v(dout0_32) AT=1210.05n

.meas tran vdout0_0ck1220 FIND v(dout0_0) AT=1230.05n

.meas tran vdout0_1ck1220 FIND v(dout0_1) AT=1230.05n

.meas tran vdout0_2ck1220 FIND v(dout0_2) AT=1230.05n

.meas tran vdout0_3ck1220 FIND v(dout0_3) AT=1230.05n

.meas tran vdout0_4ck1220 FIND v(dout0_4) AT=1230.05n

.meas tran vdout0_5ck1220 FIND v(dout0_5) AT=1230.05n

.meas tran vdout0_6ck1220 FIND v(dout0_6) AT=1230.05n

.meas tran vdout0_7ck1220 FIND v(dout0_7) AT=1230.05n

.meas tran vdout0_8ck1220 FIND v(dout0_8) AT=1230.05n

.meas tran vdout0_9ck1220 FIND v(dout0_9) AT=1230.05n

.meas tran vdout0_10ck1220 FIND v(dout0_10) AT=1230.05n

.meas tran vdout0_11ck1220 FIND v(dout0_11) AT=1230.05n

.meas tran vdout0_12ck1220 FIND v(dout0_12) AT=1230.05n

.meas tran vdout0_13ck1220 FIND v(dout0_13) AT=1230.05n

.meas tran vdout0_14ck1220 FIND v(dout0_14) AT=1230.05n

.meas tran vdout0_15ck1220 FIND v(dout0_15) AT=1230.05n

.meas tran vdout0_16ck1220 FIND v(dout0_16) AT=1230.05n

.meas tran vdout0_17ck1220 FIND v(dout0_17) AT=1230.05n

.meas tran vdout0_18ck1220 FIND v(dout0_18) AT=1230.05n

.meas tran vdout0_19ck1220 FIND v(dout0_19) AT=1230.05n

.meas tran vdout0_20ck1220 FIND v(dout0_20) AT=1230.05n

.meas tran vdout0_21ck1220 FIND v(dout0_21) AT=1230.05n

.meas tran vdout0_22ck1220 FIND v(dout0_22) AT=1230.05n

.meas tran vdout0_23ck1220 FIND v(dout0_23) AT=1230.05n

.meas tran vdout0_24ck1220 FIND v(dout0_24) AT=1230.05n

.meas tran vdout0_25ck1220 FIND v(dout0_25) AT=1230.05n

.meas tran vdout0_26ck1220 FIND v(dout0_26) AT=1230.05n

.meas tran vdout0_27ck1220 FIND v(dout0_27) AT=1230.05n

.meas tran vdout0_28ck1220 FIND v(dout0_28) AT=1230.05n

.meas tran vdout0_29ck1220 FIND v(dout0_29) AT=1230.05n

.meas tran vdout0_30ck1220 FIND v(dout0_30) AT=1230.05n

.meas tran vdout0_31ck1220 FIND v(dout0_31) AT=1230.05n

.meas tran vdout0_32ck1220 FIND v(dout0_32) AT=1230.05n

.meas tran vdout0_0ck1250 FIND v(dout0_0) AT=1260.05n

.meas tran vdout0_1ck1250 FIND v(dout0_1) AT=1260.05n

.meas tran vdout0_2ck1250 FIND v(dout0_2) AT=1260.05n

.meas tran vdout0_3ck1250 FIND v(dout0_3) AT=1260.05n

.meas tran vdout0_4ck1250 FIND v(dout0_4) AT=1260.05n

.meas tran vdout0_5ck1250 FIND v(dout0_5) AT=1260.05n

.meas tran vdout0_6ck1250 FIND v(dout0_6) AT=1260.05n

.meas tran vdout0_7ck1250 FIND v(dout0_7) AT=1260.05n

.meas tran vdout0_8ck1250 FIND v(dout0_8) AT=1260.05n

.meas tran vdout0_9ck1250 FIND v(dout0_9) AT=1260.05n

.meas tran vdout0_10ck1250 FIND v(dout0_10) AT=1260.05n

.meas tran vdout0_11ck1250 FIND v(dout0_11) AT=1260.05n

.meas tran vdout0_12ck1250 FIND v(dout0_12) AT=1260.05n

.meas tran vdout0_13ck1250 FIND v(dout0_13) AT=1260.05n

.meas tran vdout0_14ck1250 FIND v(dout0_14) AT=1260.05n

.meas tran vdout0_15ck1250 FIND v(dout0_15) AT=1260.05n

.meas tran vdout0_16ck1250 FIND v(dout0_16) AT=1260.05n

.meas tran vdout0_17ck1250 FIND v(dout0_17) AT=1260.05n

.meas tran vdout0_18ck1250 FIND v(dout0_18) AT=1260.05n

.meas tran vdout0_19ck1250 FIND v(dout0_19) AT=1260.05n

.meas tran vdout0_20ck1250 FIND v(dout0_20) AT=1260.05n

.meas tran vdout0_21ck1250 FIND v(dout0_21) AT=1260.05n

.meas tran vdout0_22ck1250 FIND v(dout0_22) AT=1260.05n

.meas tran vdout0_23ck1250 FIND v(dout0_23) AT=1260.05n

.meas tran vdout0_24ck1250 FIND v(dout0_24) AT=1260.05n

.meas tran vdout0_25ck1250 FIND v(dout0_25) AT=1260.05n

.meas tran vdout0_26ck1250 FIND v(dout0_26) AT=1260.05n

.meas tran vdout0_27ck1250 FIND v(dout0_27) AT=1260.05n

.meas tran vdout0_28ck1250 FIND v(dout0_28) AT=1260.05n

.meas tran vdout0_29ck1250 FIND v(dout0_29) AT=1260.05n

.meas tran vdout0_30ck1250 FIND v(dout0_30) AT=1260.05n

.meas tran vdout0_31ck1250 FIND v(dout0_31) AT=1260.05n

.meas tran vdout0_32ck1250 FIND v(dout0_32) AT=1260.05n

.meas tran vdout0_0ck1270 FIND v(dout0_0) AT=1280.05n

.meas tran vdout0_1ck1270 FIND v(dout0_1) AT=1280.05n

.meas tran vdout0_2ck1270 FIND v(dout0_2) AT=1280.05n

.meas tran vdout0_3ck1270 FIND v(dout0_3) AT=1280.05n

.meas tran vdout0_4ck1270 FIND v(dout0_4) AT=1280.05n

.meas tran vdout0_5ck1270 FIND v(dout0_5) AT=1280.05n

.meas tran vdout0_6ck1270 FIND v(dout0_6) AT=1280.05n

.meas tran vdout0_7ck1270 FIND v(dout0_7) AT=1280.05n

.meas tran vdout0_8ck1270 FIND v(dout0_8) AT=1280.05n

.meas tran vdout0_9ck1270 FIND v(dout0_9) AT=1280.05n

.meas tran vdout0_10ck1270 FIND v(dout0_10) AT=1280.05n

.meas tran vdout0_11ck1270 FIND v(dout0_11) AT=1280.05n

.meas tran vdout0_12ck1270 FIND v(dout0_12) AT=1280.05n

.meas tran vdout0_13ck1270 FIND v(dout0_13) AT=1280.05n

.meas tran vdout0_14ck1270 FIND v(dout0_14) AT=1280.05n

.meas tran vdout0_15ck1270 FIND v(dout0_15) AT=1280.05n

.meas tran vdout0_16ck1270 FIND v(dout0_16) AT=1280.05n

.meas tran vdout0_17ck1270 FIND v(dout0_17) AT=1280.05n

.meas tran vdout0_18ck1270 FIND v(dout0_18) AT=1280.05n

.meas tran vdout0_19ck1270 FIND v(dout0_19) AT=1280.05n

.meas tran vdout0_20ck1270 FIND v(dout0_20) AT=1280.05n

.meas tran vdout0_21ck1270 FIND v(dout0_21) AT=1280.05n

.meas tran vdout0_22ck1270 FIND v(dout0_22) AT=1280.05n

.meas tran vdout0_23ck1270 FIND v(dout0_23) AT=1280.05n

.meas tran vdout0_24ck1270 FIND v(dout0_24) AT=1280.05n

.meas tran vdout0_25ck1270 FIND v(dout0_25) AT=1280.05n

.meas tran vdout0_26ck1270 FIND v(dout0_26) AT=1280.05n

.meas tran vdout0_27ck1270 FIND v(dout0_27) AT=1280.05n

.meas tran vdout0_28ck1270 FIND v(dout0_28) AT=1280.05n

.meas tran vdout0_29ck1270 FIND v(dout0_29) AT=1280.05n

.meas tran vdout0_30ck1270 FIND v(dout0_30) AT=1280.05n

.meas tran vdout0_31ck1270 FIND v(dout0_31) AT=1280.05n

.meas tran vdout0_32ck1270 FIND v(dout0_32) AT=1280.05n

.meas tran vdout0_0ck1290 FIND v(dout0_0) AT=1300.05n

.meas tran vdout0_1ck1290 FIND v(dout0_1) AT=1300.05n

.meas tran vdout0_2ck1290 FIND v(dout0_2) AT=1300.05n

.meas tran vdout0_3ck1290 FIND v(dout0_3) AT=1300.05n

.meas tran vdout0_4ck1290 FIND v(dout0_4) AT=1300.05n

.meas tran vdout0_5ck1290 FIND v(dout0_5) AT=1300.05n

.meas tran vdout0_6ck1290 FIND v(dout0_6) AT=1300.05n

.meas tran vdout0_7ck1290 FIND v(dout0_7) AT=1300.05n

.meas tran vdout0_8ck1290 FIND v(dout0_8) AT=1300.05n

.meas tran vdout0_9ck1290 FIND v(dout0_9) AT=1300.05n

.meas tran vdout0_10ck1290 FIND v(dout0_10) AT=1300.05n

.meas tran vdout0_11ck1290 FIND v(dout0_11) AT=1300.05n

.meas tran vdout0_12ck1290 FIND v(dout0_12) AT=1300.05n

.meas tran vdout0_13ck1290 FIND v(dout0_13) AT=1300.05n

.meas tran vdout0_14ck1290 FIND v(dout0_14) AT=1300.05n

.meas tran vdout0_15ck1290 FIND v(dout0_15) AT=1300.05n

.meas tran vdout0_16ck1290 FIND v(dout0_16) AT=1300.05n

.meas tran vdout0_17ck1290 FIND v(dout0_17) AT=1300.05n

.meas tran vdout0_18ck1290 FIND v(dout0_18) AT=1300.05n

.meas tran vdout0_19ck1290 FIND v(dout0_19) AT=1300.05n

.meas tran vdout0_20ck1290 FIND v(dout0_20) AT=1300.05n

.meas tran vdout0_21ck1290 FIND v(dout0_21) AT=1300.05n

.meas tran vdout0_22ck1290 FIND v(dout0_22) AT=1300.05n

.meas tran vdout0_23ck1290 FIND v(dout0_23) AT=1300.05n

.meas tran vdout0_24ck1290 FIND v(dout0_24) AT=1300.05n

.meas tran vdout0_25ck1290 FIND v(dout0_25) AT=1300.05n

.meas tran vdout0_26ck1290 FIND v(dout0_26) AT=1300.05n

.meas tran vdout0_27ck1290 FIND v(dout0_27) AT=1300.05n

.meas tran vdout0_28ck1290 FIND v(dout0_28) AT=1300.05n

.meas tran vdout0_29ck1290 FIND v(dout0_29) AT=1300.05n

.meas tran vdout0_30ck1290 FIND v(dout0_30) AT=1300.05n

.meas tran vdout0_31ck1290 FIND v(dout0_31) AT=1300.05n

.meas tran vdout0_32ck1290 FIND v(dout0_32) AT=1300.05n

.meas tran vdout0_0ck1300 FIND v(dout0_0) AT=1310.05n

.meas tran vdout0_1ck1300 FIND v(dout0_1) AT=1310.05n

.meas tran vdout0_2ck1300 FIND v(dout0_2) AT=1310.05n

.meas tran vdout0_3ck1300 FIND v(dout0_3) AT=1310.05n

.meas tran vdout0_4ck1300 FIND v(dout0_4) AT=1310.05n

.meas tran vdout0_5ck1300 FIND v(dout0_5) AT=1310.05n

.meas tran vdout0_6ck1300 FIND v(dout0_6) AT=1310.05n

.meas tran vdout0_7ck1300 FIND v(dout0_7) AT=1310.05n

.meas tran vdout0_8ck1300 FIND v(dout0_8) AT=1310.05n

.meas tran vdout0_9ck1300 FIND v(dout0_9) AT=1310.05n

.meas tran vdout0_10ck1300 FIND v(dout0_10) AT=1310.05n

.meas tran vdout0_11ck1300 FIND v(dout0_11) AT=1310.05n

.meas tran vdout0_12ck1300 FIND v(dout0_12) AT=1310.05n

.meas tran vdout0_13ck1300 FIND v(dout0_13) AT=1310.05n

.meas tran vdout0_14ck1300 FIND v(dout0_14) AT=1310.05n

.meas tran vdout0_15ck1300 FIND v(dout0_15) AT=1310.05n

.meas tran vdout0_16ck1300 FIND v(dout0_16) AT=1310.05n

.meas tran vdout0_17ck1300 FIND v(dout0_17) AT=1310.05n

.meas tran vdout0_18ck1300 FIND v(dout0_18) AT=1310.05n

.meas tran vdout0_19ck1300 FIND v(dout0_19) AT=1310.05n

.meas tran vdout0_20ck1300 FIND v(dout0_20) AT=1310.05n

.meas tran vdout0_21ck1300 FIND v(dout0_21) AT=1310.05n

.meas tran vdout0_22ck1300 FIND v(dout0_22) AT=1310.05n

.meas tran vdout0_23ck1300 FIND v(dout0_23) AT=1310.05n

.meas tran vdout0_24ck1300 FIND v(dout0_24) AT=1310.05n

.meas tran vdout0_25ck1300 FIND v(dout0_25) AT=1310.05n

.meas tran vdout0_26ck1300 FIND v(dout0_26) AT=1310.05n

.meas tran vdout0_27ck1300 FIND v(dout0_27) AT=1310.05n

.meas tran vdout0_28ck1300 FIND v(dout0_28) AT=1310.05n

.meas tran vdout0_29ck1300 FIND v(dout0_29) AT=1310.05n

.meas tran vdout0_30ck1300 FIND v(dout0_30) AT=1310.05n

.meas tran vdout0_31ck1300 FIND v(dout0_31) AT=1310.05n

.meas tran vdout0_32ck1300 FIND v(dout0_32) AT=1310.05n

.meas tran vdout0_0ck1340 FIND v(dout0_0) AT=1350.05n

.meas tran vdout0_1ck1340 FIND v(dout0_1) AT=1350.05n

.meas tran vdout0_2ck1340 FIND v(dout0_2) AT=1350.05n

.meas tran vdout0_3ck1340 FIND v(dout0_3) AT=1350.05n

.meas tran vdout0_4ck1340 FIND v(dout0_4) AT=1350.05n

.meas tran vdout0_5ck1340 FIND v(dout0_5) AT=1350.05n

.meas tran vdout0_6ck1340 FIND v(dout0_6) AT=1350.05n

.meas tran vdout0_7ck1340 FIND v(dout0_7) AT=1350.05n

.meas tran vdout0_8ck1340 FIND v(dout0_8) AT=1350.05n

.meas tran vdout0_9ck1340 FIND v(dout0_9) AT=1350.05n

.meas tran vdout0_10ck1340 FIND v(dout0_10) AT=1350.05n

.meas tran vdout0_11ck1340 FIND v(dout0_11) AT=1350.05n

.meas tran vdout0_12ck1340 FIND v(dout0_12) AT=1350.05n

.meas tran vdout0_13ck1340 FIND v(dout0_13) AT=1350.05n

.meas tran vdout0_14ck1340 FIND v(dout0_14) AT=1350.05n

.meas tran vdout0_15ck1340 FIND v(dout0_15) AT=1350.05n

.meas tran vdout0_16ck1340 FIND v(dout0_16) AT=1350.05n

.meas tran vdout0_17ck1340 FIND v(dout0_17) AT=1350.05n

.meas tran vdout0_18ck1340 FIND v(dout0_18) AT=1350.05n

.meas tran vdout0_19ck1340 FIND v(dout0_19) AT=1350.05n

.meas tran vdout0_20ck1340 FIND v(dout0_20) AT=1350.05n

.meas tran vdout0_21ck1340 FIND v(dout0_21) AT=1350.05n

.meas tran vdout0_22ck1340 FIND v(dout0_22) AT=1350.05n

.meas tran vdout0_23ck1340 FIND v(dout0_23) AT=1350.05n

.meas tran vdout0_24ck1340 FIND v(dout0_24) AT=1350.05n

.meas tran vdout0_25ck1340 FIND v(dout0_25) AT=1350.05n

.meas tran vdout0_26ck1340 FIND v(dout0_26) AT=1350.05n

.meas tran vdout0_27ck1340 FIND v(dout0_27) AT=1350.05n

.meas tran vdout0_28ck1340 FIND v(dout0_28) AT=1350.05n

.meas tran vdout0_29ck1340 FIND v(dout0_29) AT=1350.05n

.meas tran vdout0_30ck1340 FIND v(dout0_30) AT=1350.05n

.meas tran vdout0_31ck1340 FIND v(dout0_31) AT=1350.05n

.meas tran vdout0_32ck1340 FIND v(dout0_32) AT=1350.05n

.meas tran vdout0_0ck1350 FIND v(dout0_0) AT=1360.05n

.meas tran vdout0_1ck1350 FIND v(dout0_1) AT=1360.05n

.meas tran vdout0_2ck1350 FIND v(dout0_2) AT=1360.05n

.meas tran vdout0_3ck1350 FIND v(dout0_3) AT=1360.05n

.meas tran vdout0_4ck1350 FIND v(dout0_4) AT=1360.05n

.meas tran vdout0_5ck1350 FIND v(dout0_5) AT=1360.05n

.meas tran vdout0_6ck1350 FIND v(dout0_6) AT=1360.05n

.meas tran vdout0_7ck1350 FIND v(dout0_7) AT=1360.05n

.meas tran vdout0_8ck1350 FIND v(dout0_8) AT=1360.05n

.meas tran vdout0_9ck1350 FIND v(dout0_9) AT=1360.05n

.meas tran vdout0_10ck1350 FIND v(dout0_10) AT=1360.05n

.meas tran vdout0_11ck1350 FIND v(dout0_11) AT=1360.05n

.meas tran vdout0_12ck1350 FIND v(dout0_12) AT=1360.05n

.meas tran vdout0_13ck1350 FIND v(dout0_13) AT=1360.05n

.meas tran vdout0_14ck1350 FIND v(dout0_14) AT=1360.05n

.meas tran vdout0_15ck1350 FIND v(dout0_15) AT=1360.05n

.meas tran vdout0_16ck1350 FIND v(dout0_16) AT=1360.05n

.meas tran vdout0_17ck1350 FIND v(dout0_17) AT=1360.05n

.meas tran vdout0_18ck1350 FIND v(dout0_18) AT=1360.05n

.meas tran vdout0_19ck1350 FIND v(dout0_19) AT=1360.05n

.meas tran vdout0_20ck1350 FIND v(dout0_20) AT=1360.05n

.meas tran vdout0_21ck1350 FIND v(dout0_21) AT=1360.05n

.meas tran vdout0_22ck1350 FIND v(dout0_22) AT=1360.05n

.meas tran vdout0_23ck1350 FIND v(dout0_23) AT=1360.05n

.meas tran vdout0_24ck1350 FIND v(dout0_24) AT=1360.05n

.meas tran vdout0_25ck1350 FIND v(dout0_25) AT=1360.05n

.meas tran vdout0_26ck1350 FIND v(dout0_26) AT=1360.05n

.meas tran vdout0_27ck1350 FIND v(dout0_27) AT=1360.05n

.meas tran vdout0_28ck1350 FIND v(dout0_28) AT=1360.05n

.meas tran vdout0_29ck1350 FIND v(dout0_29) AT=1360.05n

.meas tran vdout0_30ck1350 FIND v(dout0_30) AT=1360.05n

.meas tran vdout0_31ck1350 FIND v(dout0_31) AT=1360.05n

.meas tran vdout0_32ck1350 FIND v(dout0_32) AT=1360.05n

.meas tran vdout0_0ck1360 FIND v(dout0_0) AT=1370.05n

.meas tran vdout0_1ck1360 FIND v(dout0_1) AT=1370.05n

.meas tran vdout0_2ck1360 FIND v(dout0_2) AT=1370.05n

.meas tran vdout0_3ck1360 FIND v(dout0_3) AT=1370.05n

.meas tran vdout0_4ck1360 FIND v(dout0_4) AT=1370.05n

.meas tran vdout0_5ck1360 FIND v(dout0_5) AT=1370.05n

.meas tran vdout0_6ck1360 FIND v(dout0_6) AT=1370.05n

.meas tran vdout0_7ck1360 FIND v(dout0_7) AT=1370.05n

.meas tran vdout0_8ck1360 FIND v(dout0_8) AT=1370.05n

.meas tran vdout0_9ck1360 FIND v(dout0_9) AT=1370.05n

.meas tran vdout0_10ck1360 FIND v(dout0_10) AT=1370.05n

.meas tran vdout0_11ck1360 FIND v(dout0_11) AT=1370.05n

.meas tran vdout0_12ck1360 FIND v(dout0_12) AT=1370.05n

.meas tran vdout0_13ck1360 FIND v(dout0_13) AT=1370.05n

.meas tran vdout0_14ck1360 FIND v(dout0_14) AT=1370.05n

.meas tran vdout0_15ck1360 FIND v(dout0_15) AT=1370.05n

.meas tran vdout0_16ck1360 FIND v(dout0_16) AT=1370.05n

.meas tran vdout0_17ck1360 FIND v(dout0_17) AT=1370.05n

.meas tran vdout0_18ck1360 FIND v(dout0_18) AT=1370.05n

.meas tran vdout0_19ck1360 FIND v(dout0_19) AT=1370.05n

.meas tran vdout0_20ck1360 FIND v(dout0_20) AT=1370.05n

.meas tran vdout0_21ck1360 FIND v(dout0_21) AT=1370.05n

.meas tran vdout0_22ck1360 FIND v(dout0_22) AT=1370.05n

.meas tran vdout0_23ck1360 FIND v(dout0_23) AT=1370.05n

.meas tran vdout0_24ck1360 FIND v(dout0_24) AT=1370.05n

.meas tran vdout0_25ck1360 FIND v(dout0_25) AT=1370.05n

.meas tran vdout0_26ck1360 FIND v(dout0_26) AT=1370.05n

.meas tran vdout0_27ck1360 FIND v(dout0_27) AT=1370.05n

.meas tran vdout0_28ck1360 FIND v(dout0_28) AT=1370.05n

.meas tran vdout0_29ck1360 FIND v(dout0_29) AT=1370.05n

.meas tran vdout0_30ck1360 FIND v(dout0_30) AT=1370.05n

.meas tran vdout0_31ck1360 FIND v(dout0_31) AT=1370.05n

.meas tran vdout0_32ck1360 FIND v(dout0_32) AT=1370.05n

.meas tran vdout0_0ck1400 FIND v(dout0_0) AT=1410.05n

.meas tran vdout0_1ck1400 FIND v(dout0_1) AT=1410.05n

.meas tran vdout0_2ck1400 FIND v(dout0_2) AT=1410.05n

.meas tran vdout0_3ck1400 FIND v(dout0_3) AT=1410.05n

.meas tran vdout0_4ck1400 FIND v(dout0_4) AT=1410.05n

.meas tran vdout0_5ck1400 FIND v(dout0_5) AT=1410.05n

.meas tran vdout0_6ck1400 FIND v(dout0_6) AT=1410.05n

.meas tran vdout0_7ck1400 FIND v(dout0_7) AT=1410.05n

.meas tran vdout0_8ck1400 FIND v(dout0_8) AT=1410.05n

.meas tran vdout0_9ck1400 FIND v(dout0_9) AT=1410.05n

.meas tran vdout0_10ck1400 FIND v(dout0_10) AT=1410.05n

.meas tran vdout0_11ck1400 FIND v(dout0_11) AT=1410.05n

.meas tran vdout0_12ck1400 FIND v(dout0_12) AT=1410.05n

.meas tran vdout0_13ck1400 FIND v(dout0_13) AT=1410.05n

.meas tran vdout0_14ck1400 FIND v(dout0_14) AT=1410.05n

.meas tran vdout0_15ck1400 FIND v(dout0_15) AT=1410.05n

.meas tran vdout0_16ck1400 FIND v(dout0_16) AT=1410.05n

.meas tran vdout0_17ck1400 FIND v(dout0_17) AT=1410.05n

.meas tran vdout0_18ck1400 FIND v(dout0_18) AT=1410.05n

.meas tran vdout0_19ck1400 FIND v(dout0_19) AT=1410.05n

.meas tran vdout0_20ck1400 FIND v(dout0_20) AT=1410.05n

.meas tran vdout0_21ck1400 FIND v(dout0_21) AT=1410.05n

.meas tran vdout0_22ck1400 FIND v(dout0_22) AT=1410.05n

.meas tran vdout0_23ck1400 FIND v(dout0_23) AT=1410.05n

.meas tran vdout0_24ck1400 FIND v(dout0_24) AT=1410.05n

.meas tran vdout0_25ck1400 FIND v(dout0_25) AT=1410.05n

.meas tran vdout0_26ck1400 FIND v(dout0_26) AT=1410.05n

.meas tran vdout0_27ck1400 FIND v(dout0_27) AT=1410.05n

.meas tran vdout0_28ck1400 FIND v(dout0_28) AT=1410.05n

.meas tran vdout0_29ck1400 FIND v(dout0_29) AT=1410.05n

.meas tran vdout0_30ck1400 FIND v(dout0_30) AT=1410.05n

.meas tran vdout0_31ck1400 FIND v(dout0_31) AT=1410.05n

.meas tran vdout0_32ck1400 FIND v(dout0_32) AT=1410.05n

.meas tran vdout0_0ck1420 FIND v(dout0_0) AT=1430.05n

.meas tran vdout0_1ck1420 FIND v(dout0_1) AT=1430.05n

.meas tran vdout0_2ck1420 FIND v(dout0_2) AT=1430.05n

.meas tran vdout0_3ck1420 FIND v(dout0_3) AT=1430.05n

.meas tran vdout0_4ck1420 FIND v(dout0_4) AT=1430.05n

.meas tran vdout0_5ck1420 FIND v(dout0_5) AT=1430.05n

.meas tran vdout0_6ck1420 FIND v(dout0_6) AT=1430.05n

.meas tran vdout0_7ck1420 FIND v(dout0_7) AT=1430.05n

.meas tran vdout0_8ck1420 FIND v(dout0_8) AT=1430.05n

.meas tran vdout0_9ck1420 FIND v(dout0_9) AT=1430.05n

.meas tran vdout0_10ck1420 FIND v(dout0_10) AT=1430.05n

.meas tran vdout0_11ck1420 FIND v(dout0_11) AT=1430.05n

.meas tran vdout0_12ck1420 FIND v(dout0_12) AT=1430.05n

.meas tran vdout0_13ck1420 FIND v(dout0_13) AT=1430.05n

.meas tran vdout0_14ck1420 FIND v(dout0_14) AT=1430.05n

.meas tran vdout0_15ck1420 FIND v(dout0_15) AT=1430.05n

.meas tran vdout0_16ck1420 FIND v(dout0_16) AT=1430.05n

.meas tran vdout0_17ck1420 FIND v(dout0_17) AT=1430.05n

.meas tran vdout0_18ck1420 FIND v(dout0_18) AT=1430.05n

.meas tran vdout0_19ck1420 FIND v(dout0_19) AT=1430.05n

.meas tran vdout0_20ck1420 FIND v(dout0_20) AT=1430.05n

.meas tran vdout0_21ck1420 FIND v(dout0_21) AT=1430.05n

.meas tran vdout0_22ck1420 FIND v(dout0_22) AT=1430.05n

.meas tran vdout0_23ck1420 FIND v(dout0_23) AT=1430.05n

.meas tran vdout0_24ck1420 FIND v(dout0_24) AT=1430.05n

.meas tran vdout0_25ck1420 FIND v(dout0_25) AT=1430.05n

.meas tran vdout0_26ck1420 FIND v(dout0_26) AT=1430.05n

.meas tran vdout0_27ck1420 FIND v(dout0_27) AT=1430.05n

.meas tran vdout0_28ck1420 FIND v(dout0_28) AT=1430.05n

.meas tran vdout0_29ck1420 FIND v(dout0_29) AT=1430.05n

.meas tran vdout0_30ck1420 FIND v(dout0_30) AT=1430.05n

.meas tran vdout0_31ck1420 FIND v(dout0_31) AT=1430.05n

.meas tran vdout0_32ck1420 FIND v(dout0_32) AT=1430.05n

.meas tran vdout0_0ck1430 FIND v(dout0_0) AT=1440.05n

.meas tran vdout0_1ck1430 FIND v(dout0_1) AT=1440.05n

.meas tran vdout0_2ck1430 FIND v(dout0_2) AT=1440.05n

.meas tran vdout0_3ck1430 FIND v(dout0_3) AT=1440.05n

.meas tran vdout0_4ck1430 FIND v(dout0_4) AT=1440.05n

.meas tran vdout0_5ck1430 FIND v(dout0_5) AT=1440.05n

.meas tran vdout0_6ck1430 FIND v(dout0_6) AT=1440.05n

.meas tran vdout0_7ck1430 FIND v(dout0_7) AT=1440.05n

.meas tran vdout0_8ck1430 FIND v(dout0_8) AT=1440.05n

.meas tran vdout0_9ck1430 FIND v(dout0_9) AT=1440.05n

.meas tran vdout0_10ck1430 FIND v(dout0_10) AT=1440.05n

.meas tran vdout0_11ck1430 FIND v(dout0_11) AT=1440.05n

.meas tran vdout0_12ck1430 FIND v(dout0_12) AT=1440.05n

.meas tran vdout0_13ck1430 FIND v(dout0_13) AT=1440.05n

.meas tran vdout0_14ck1430 FIND v(dout0_14) AT=1440.05n

.meas tran vdout0_15ck1430 FIND v(dout0_15) AT=1440.05n

.meas tran vdout0_16ck1430 FIND v(dout0_16) AT=1440.05n

.meas tran vdout0_17ck1430 FIND v(dout0_17) AT=1440.05n

.meas tran vdout0_18ck1430 FIND v(dout0_18) AT=1440.05n

.meas tran vdout0_19ck1430 FIND v(dout0_19) AT=1440.05n

.meas tran vdout0_20ck1430 FIND v(dout0_20) AT=1440.05n

.meas tran vdout0_21ck1430 FIND v(dout0_21) AT=1440.05n

.meas tran vdout0_22ck1430 FIND v(dout0_22) AT=1440.05n

.meas tran vdout0_23ck1430 FIND v(dout0_23) AT=1440.05n

.meas tran vdout0_24ck1430 FIND v(dout0_24) AT=1440.05n

.meas tran vdout0_25ck1430 FIND v(dout0_25) AT=1440.05n

.meas tran vdout0_26ck1430 FIND v(dout0_26) AT=1440.05n

.meas tran vdout0_27ck1430 FIND v(dout0_27) AT=1440.05n

.meas tran vdout0_28ck1430 FIND v(dout0_28) AT=1440.05n

.meas tran vdout0_29ck1430 FIND v(dout0_29) AT=1440.05n

.meas tran vdout0_30ck1430 FIND v(dout0_30) AT=1440.05n

.meas tran vdout0_31ck1430 FIND v(dout0_31) AT=1440.05n

.meas tran vdout0_32ck1430 FIND v(dout0_32) AT=1440.05n

.meas tran vdout0_0ck1440 FIND v(dout0_0) AT=1450.05n

.meas tran vdout0_1ck1440 FIND v(dout0_1) AT=1450.05n

.meas tran vdout0_2ck1440 FIND v(dout0_2) AT=1450.05n

.meas tran vdout0_3ck1440 FIND v(dout0_3) AT=1450.05n

.meas tran vdout0_4ck1440 FIND v(dout0_4) AT=1450.05n

.meas tran vdout0_5ck1440 FIND v(dout0_5) AT=1450.05n

.meas tran vdout0_6ck1440 FIND v(dout0_6) AT=1450.05n

.meas tran vdout0_7ck1440 FIND v(dout0_7) AT=1450.05n

.meas tran vdout0_8ck1440 FIND v(dout0_8) AT=1450.05n

.meas tran vdout0_9ck1440 FIND v(dout0_9) AT=1450.05n

.meas tran vdout0_10ck1440 FIND v(dout0_10) AT=1450.05n

.meas tran vdout0_11ck1440 FIND v(dout0_11) AT=1450.05n

.meas tran vdout0_12ck1440 FIND v(dout0_12) AT=1450.05n

.meas tran vdout0_13ck1440 FIND v(dout0_13) AT=1450.05n

.meas tran vdout0_14ck1440 FIND v(dout0_14) AT=1450.05n

.meas tran vdout0_15ck1440 FIND v(dout0_15) AT=1450.05n

.meas tran vdout0_16ck1440 FIND v(dout0_16) AT=1450.05n

.meas tran vdout0_17ck1440 FIND v(dout0_17) AT=1450.05n

.meas tran vdout0_18ck1440 FIND v(dout0_18) AT=1450.05n

.meas tran vdout0_19ck1440 FIND v(dout0_19) AT=1450.05n

.meas tran vdout0_20ck1440 FIND v(dout0_20) AT=1450.05n

.meas tran vdout0_21ck1440 FIND v(dout0_21) AT=1450.05n

.meas tran vdout0_22ck1440 FIND v(dout0_22) AT=1450.05n

.meas tran vdout0_23ck1440 FIND v(dout0_23) AT=1450.05n

.meas tran vdout0_24ck1440 FIND v(dout0_24) AT=1450.05n

.meas tran vdout0_25ck1440 FIND v(dout0_25) AT=1450.05n

.meas tran vdout0_26ck1440 FIND v(dout0_26) AT=1450.05n

.meas tran vdout0_27ck1440 FIND v(dout0_27) AT=1450.05n

.meas tran vdout0_28ck1440 FIND v(dout0_28) AT=1450.05n

.meas tran vdout0_29ck1440 FIND v(dout0_29) AT=1450.05n

.meas tran vdout0_30ck1440 FIND v(dout0_30) AT=1450.05n

.meas tran vdout0_31ck1440 FIND v(dout0_31) AT=1450.05n

.meas tran vdout0_32ck1440 FIND v(dout0_32) AT=1450.05n

.meas tran vdout0_0ck1450 FIND v(dout0_0) AT=1460.05n

.meas tran vdout0_1ck1450 FIND v(dout0_1) AT=1460.05n

.meas tran vdout0_2ck1450 FIND v(dout0_2) AT=1460.05n

.meas tran vdout0_3ck1450 FIND v(dout0_3) AT=1460.05n

.meas tran vdout0_4ck1450 FIND v(dout0_4) AT=1460.05n

.meas tran vdout0_5ck1450 FIND v(dout0_5) AT=1460.05n

.meas tran vdout0_6ck1450 FIND v(dout0_6) AT=1460.05n

.meas tran vdout0_7ck1450 FIND v(dout0_7) AT=1460.05n

.meas tran vdout0_8ck1450 FIND v(dout0_8) AT=1460.05n

.meas tran vdout0_9ck1450 FIND v(dout0_9) AT=1460.05n

.meas tran vdout0_10ck1450 FIND v(dout0_10) AT=1460.05n

.meas tran vdout0_11ck1450 FIND v(dout0_11) AT=1460.05n

.meas tran vdout0_12ck1450 FIND v(dout0_12) AT=1460.05n

.meas tran vdout0_13ck1450 FIND v(dout0_13) AT=1460.05n

.meas tran vdout0_14ck1450 FIND v(dout0_14) AT=1460.05n

.meas tran vdout0_15ck1450 FIND v(dout0_15) AT=1460.05n

.meas tran vdout0_16ck1450 FIND v(dout0_16) AT=1460.05n

.meas tran vdout0_17ck1450 FIND v(dout0_17) AT=1460.05n

.meas tran vdout0_18ck1450 FIND v(dout0_18) AT=1460.05n

.meas tran vdout0_19ck1450 FIND v(dout0_19) AT=1460.05n

.meas tran vdout0_20ck1450 FIND v(dout0_20) AT=1460.05n

.meas tran vdout0_21ck1450 FIND v(dout0_21) AT=1460.05n

.meas tran vdout0_22ck1450 FIND v(dout0_22) AT=1460.05n

.meas tran vdout0_23ck1450 FIND v(dout0_23) AT=1460.05n

.meas tran vdout0_24ck1450 FIND v(dout0_24) AT=1460.05n

.meas tran vdout0_25ck1450 FIND v(dout0_25) AT=1460.05n

.meas tran vdout0_26ck1450 FIND v(dout0_26) AT=1460.05n

.meas tran vdout0_27ck1450 FIND v(dout0_27) AT=1460.05n

.meas tran vdout0_28ck1450 FIND v(dout0_28) AT=1460.05n

.meas tran vdout0_29ck1450 FIND v(dout0_29) AT=1460.05n

.meas tran vdout0_30ck1450 FIND v(dout0_30) AT=1460.05n

.meas tran vdout0_31ck1450 FIND v(dout0_31) AT=1460.05n

.meas tran vdout0_32ck1450 FIND v(dout0_32) AT=1460.05n

.meas tran vdout0_0ck1460 FIND v(dout0_0) AT=1470.05n

.meas tran vdout0_1ck1460 FIND v(dout0_1) AT=1470.05n

.meas tran vdout0_2ck1460 FIND v(dout0_2) AT=1470.05n

.meas tran vdout0_3ck1460 FIND v(dout0_3) AT=1470.05n

.meas tran vdout0_4ck1460 FIND v(dout0_4) AT=1470.05n

.meas tran vdout0_5ck1460 FIND v(dout0_5) AT=1470.05n

.meas tran vdout0_6ck1460 FIND v(dout0_6) AT=1470.05n

.meas tran vdout0_7ck1460 FIND v(dout0_7) AT=1470.05n

.meas tran vdout0_8ck1460 FIND v(dout0_8) AT=1470.05n

.meas tran vdout0_9ck1460 FIND v(dout0_9) AT=1470.05n

.meas tran vdout0_10ck1460 FIND v(dout0_10) AT=1470.05n

.meas tran vdout0_11ck1460 FIND v(dout0_11) AT=1470.05n

.meas tran vdout0_12ck1460 FIND v(dout0_12) AT=1470.05n

.meas tran vdout0_13ck1460 FIND v(dout0_13) AT=1470.05n

.meas tran vdout0_14ck1460 FIND v(dout0_14) AT=1470.05n

.meas tran vdout0_15ck1460 FIND v(dout0_15) AT=1470.05n

.meas tran vdout0_16ck1460 FIND v(dout0_16) AT=1470.05n

.meas tran vdout0_17ck1460 FIND v(dout0_17) AT=1470.05n

.meas tran vdout0_18ck1460 FIND v(dout0_18) AT=1470.05n

.meas tran vdout0_19ck1460 FIND v(dout0_19) AT=1470.05n

.meas tran vdout0_20ck1460 FIND v(dout0_20) AT=1470.05n

.meas tran vdout0_21ck1460 FIND v(dout0_21) AT=1470.05n

.meas tran vdout0_22ck1460 FIND v(dout0_22) AT=1470.05n

.meas tran vdout0_23ck1460 FIND v(dout0_23) AT=1470.05n

.meas tran vdout0_24ck1460 FIND v(dout0_24) AT=1470.05n

.meas tran vdout0_25ck1460 FIND v(dout0_25) AT=1470.05n

.meas tran vdout0_26ck1460 FIND v(dout0_26) AT=1470.05n

.meas tran vdout0_27ck1460 FIND v(dout0_27) AT=1470.05n

.meas tran vdout0_28ck1460 FIND v(dout0_28) AT=1470.05n

.meas tran vdout0_29ck1460 FIND v(dout0_29) AT=1470.05n

.meas tran vdout0_30ck1460 FIND v(dout0_30) AT=1470.05n

.meas tran vdout0_31ck1460 FIND v(dout0_31) AT=1470.05n

.meas tran vdout0_32ck1460 FIND v(dout0_32) AT=1470.05n

.meas tran vdout0_0ck1470 FIND v(dout0_0) AT=1480.05n

.meas tran vdout0_1ck1470 FIND v(dout0_1) AT=1480.05n

.meas tran vdout0_2ck1470 FIND v(dout0_2) AT=1480.05n

.meas tran vdout0_3ck1470 FIND v(dout0_3) AT=1480.05n

.meas tran vdout0_4ck1470 FIND v(dout0_4) AT=1480.05n

.meas tran vdout0_5ck1470 FIND v(dout0_5) AT=1480.05n

.meas tran vdout0_6ck1470 FIND v(dout0_6) AT=1480.05n

.meas tran vdout0_7ck1470 FIND v(dout0_7) AT=1480.05n

.meas tran vdout0_8ck1470 FIND v(dout0_8) AT=1480.05n

.meas tran vdout0_9ck1470 FIND v(dout0_9) AT=1480.05n

.meas tran vdout0_10ck1470 FIND v(dout0_10) AT=1480.05n

.meas tran vdout0_11ck1470 FIND v(dout0_11) AT=1480.05n

.meas tran vdout0_12ck1470 FIND v(dout0_12) AT=1480.05n

.meas tran vdout0_13ck1470 FIND v(dout0_13) AT=1480.05n

.meas tran vdout0_14ck1470 FIND v(dout0_14) AT=1480.05n

.meas tran vdout0_15ck1470 FIND v(dout0_15) AT=1480.05n

.meas tran vdout0_16ck1470 FIND v(dout0_16) AT=1480.05n

.meas tran vdout0_17ck1470 FIND v(dout0_17) AT=1480.05n

.meas tran vdout0_18ck1470 FIND v(dout0_18) AT=1480.05n

.meas tran vdout0_19ck1470 FIND v(dout0_19) AT=1480.05n

.meas tran vdout0_20ck1470 FIND v(dout0_20) AT=1480.05n

.meas tran vdout0_21ck1470 FIND v(dout0_21) AT=1480.05n

.meas tran vdout0_22ck1470 FIND v(dout0_22) AT=1480.05n

.meas tran vdout0_23ck1470 FIND v(dout0_23) AT=1480.05n

.meas tran vdout0_24ck1470 FIND v(dout0_24) AT=1480.05n

.meas tran vdout0_25ck1470 FIND v(dout0_25) AT=1480.05n

.meas tran vdout0_26ck1470 FIND v(dout0_26) AT=1480.05n

.meas tran vdout0_27ck1470 FIND v(dout0_27) AT=1480.05n

.meas tran vdout0_28ck1470 FIND v(dout0_28) AT=1480.05n

.meas tran vdout0_29ck1470 FIND v(dout0_29) AT=1480.05n

.meas tran vdout0_30ck1470 FIND v(dout0_30) AT=1480.05n

.meas tran vdout0_31ck1470 FIND v(dout0_31) AT=1480.05n

.meas tran vdout0_32ck1470 FIND v(dout0_32) AT=1480.05n

.meas tran vdout0_0ck1500 FIND v(dout0_0) AT=1510.05n

.meas tran vdout0_1ck1500 FIND v(dout0_1) AT=1510.05n

.meas tran vdout0_2ck1500 FIND v(dout0_2) AT=1510.05n

.meas tran vdout0_3ck1500 FIND v(dout0_3) AT=1510.05n

.meas tran vdout0_4ck1500 FIND v(dout0_4) AT=1510.05n

.meas tran vdout0_5ck1500 FIND v(dout0_5) AT=1510.05n

.meas tran vdout0_6ck1500 FIND v(dout0_6) AT=1510.05n

.meas tran vdout0_7ck1500 FIND v(dout0_7) AT=1510.05n

.meas tran vdout0_8ck1500 FIND v(dout0_8) AT=1510.05n

.meas tran vdout0_9ck1500 FIND v(dout0_9) AT=1510.05n

.meas tran vdout0_10ck1500 FIND v(dout0_10) AT=1510.05n

.meas tran vdout0_11ck1500 FIND v(dout0_11) AT=1510.05n

.meas tran vdout0_12ck1500 FIND v(dout0_12) AT=1510.05n

.meas tran vdout0_13ck1500 FIND v(dout0_13) AT=1510.05n

.meas tran vdout0_14ck1500 FIND v(dout0_14) AT=1510.05n

.meas tran vdout0_15ck1500 FIND v(dout0_15) AT=1510.05n

.meas tran vdout0_16ck1500 FIND v(dout0_16) AT=1510.05n

.meas tran vdout0_17ck1500 FIND v(dout0_17) AT=1510.05n

.meas tran vdout0_18ck1500 FIND v(dout0_18) AT=1510.05n

.meas tran vdout0_19ck1500 FIND v(dout0_19) AT=1510.05n

.meas tran vdout0_20ck1500 FIND v(dout0_20) AT=1510.05n

.meas tran vdout0_21ck1500 FIND v(dout0_21) AT=1510.05n

.meas tran vdout0_22ck1500 FIND v(dout0_22) AT=1510.05n

.meas tran vdout0_23ck1500 FIND v(dout0_23) AT=1510.05n

.meas tran vdout0_24ck1500 FIND v(dout0_24) AT=1510.05n

.meas tran vdout0_25ck1500 FIND v(dout0_25) AT=1510.05n

.meas tran vdout0_26ck1500 FIND v(dout0_26) AT=1510.05n

.meas tran vdout0_27ck1500 FIND v(dout0_27) AT=1510.05n

.meas tran vdout0_28ck1500 FIND v(dout0_28) AT=1510.05n

.meas tran vdout0_29ck1500 FIND v(dout0_29) AT=1510.05n

.meas tran vdout0_30ck1500 FIND v(dout0_30) AT=1510.05n

.meas tran vdout0_31ck1500 FIND v(dout0_31) AT=1510.05n

.meas tran vdout0_32ck1500 FIND v(dout0_32) AT=1510.05n

.meas tran vdout0_0ck1510 FIND v(dout0_0) AT=1520.05n

.meas tran vdout0_1ck1510 FIND v(dout0_1) AT=1520.05n

.meas tran vdout0_2ck1510 FIND v(dout0_2) AT=1520.05n

.meas tran vdout0_3ck1510 FIND v(dout0_3) AT=1520.05n

.meas tran vdout0_4ck1510 FIND v(dout0_4) AT=1520.05n

.meas tran vdout0_5ck1510 FIND v(dout0_5) AT=1520.05n

.meas tran vdout0_6ck1510 FIND v(dout0_6) AT=1520.05n

.meas tran vdout0_7ck1510 FIND v(dout0_7) AT=1520.05n

.meas tran vdout0_8ck1510 FIND v(dout0_8) AT=1520.05n

.meas tran vdout0_9ck1510 FIND v(dout0_9) AT=1520.05n

.meas tran vdout0_10ck1510 FIND v(dout0_10) AT=1520.05n

.meas tran vdout0_11ck1510 FIND v(dout0_11) AT=1520.05n

.meas tran vdout0_12ck1510 FIND v(dout0_12) AT=1520.05n

.meas tran vdout0_13ck1510 FIND v(dout0_13) AT=1520.05n

.meas tran vdout0_14ck1510 FIND v(dout0_14) AT=1520.05n

.meas tran vdout0_15ck1510 FIND v(dout0_15) AT=1520.05n

.meas tran vdout0_16ck1510 FIND v(dout0_16) AT=1520.05n

.meas tran vdout0_17ck1510 FIND v(dout0_17) AT=1520.05n

.meas tran vdout0_18ck1510 FIND v(dout0_18) AT=1520.05n

.meas tran vdout0_19ck1510 FIND v(dout0_19) AT=1520.05n

.meas tran vdout0_20ck1510 FIND v(dout0_20) AT=1520.05n

.meas tran vdout0_21ck1510 FIND v(dout0_21) AT=1520.05n

.meas tran vdout0_22ck1510 FIND v(dout0_22) AT=1520.05n

.meas tran vdout0_23ck1510 FIND v(dout0_23) AT=1520.05n

.meas tran vdout0_24ck1510 FIND v(dout0_24) AT=1520.05n

.meas tran vdout0_25ck1510 FIND v(dout0_25) AT=1520.05n

.meas tran vdout0_26ck1510 FIND v(dout0_26) AT=1520.05n

.meas tran vdout0_27ck1510 FIND v(dout0_27) AT=1520.05n

.meas tran vdout0_28ck1510 FIND v(dout0_28) AT=1520.05n

.meas tran vdout0_29ck1510 FIND v(dout0_29) AT=1520.05n

.meas tran vdout0_30ck1510 FIND v(dout0_30) AT=1520.05n

.meas tran vdout0_31ck1510 FIND v(dout0_31) AT=1520.05n

.meas tran vdout0_32ck1510 FIND v(dout0_32) AT=1520.05n

.meas tran vdout0_0ck1550 FIND v(dout0_0) AT=1560.05n

.meas tran vdout0_1ck1550 FIND v(dout0_1) AT=1560.05n

.meas tran vdout0_2ck1550 FIND v(dout0_2) AT=1560.05n

.meas tran vdout0_3ck1550 FIND v(dout0_3) AT=1560.05n

.meas tran vdout0_4ck1550 FIND v(dout0_4) AT=1560.05n

.meas tran vdout0_5ck1550 FIND v(dout0_5) AT=1560.05n

.meas tran vdout0_6ck1550 FIND v(dout0_6) AT=1560.05n

.meas tran vdout0_7ck1550 FIND v(dout0_7) AT=1560.05n

.meas tran vdout0_8ck1550 FIND v(dout0_8) AT=1560.05n

.meas tran vdout0_9ck1550 FIND v(dout0_9) AT=1560.05n

.meas tran vdout0_10ck1550 FIND v(dout0_10) AT=1560.05n

.meas tran vdout0_11ck1550 FIND v(dout0_11) AT=1560.05n

.meas tran vdout0_12ck1550 FIND v(dout0_12) AT=1560.05n

.meas tran vdout0_13ck1550 FIND v(dout0_13) AT=1560.05n

.meas tran vdout0_14ck1550 FIND v(dout0_14) AT=1560.05n

.meas tran vdout0_15ck1550 FIND v(dout0_15) AT=1560.05n

.meas tran vdout0_16ck1550 FIND v(dout0_16) AT=1560.05n

.meas tran vdout0_17ck1550 FIND v(dout0_17) AT=1560.05n

.meas tran vdout0_18ck1550 FIND v(dout0_18) AT=1560.05n

.meas tran vdout0_19ck1550 FIND v(dout0_19) AT=1560.05n

.meas tran vdout0_20ck1550 FIND v(dout0_20) AT=1560.05n

.meas tran vdout0_21ck1550 FIND v(dout0_21) AT=1560.05n

.meas tran vdout0_22ck1550 FIND v(dout0_22) AT=1560.05n

.meas tran vdout0_23ck1550 FIND v(dout0_23) AT=1560.05n

.meas tran vdout0_24ck1550 FIND v(dout0_24) AT=1560.05n

.meas tran vdout0_25ck1550 FIND v(dout0_25) AT=1560.05n

.meas tran vdout0_26ck1550 FIND v(dout0_26) AT=1560.05n

.meas tran vdout0_27ck1550 FIND v(dout0_27) AT=1560.05n

.meas tran vdout0_28ck1550 FIND v(dout0_28) AT=1560.05n

.meas tran vdout0_29ck1550 FIND v(dout0_29) AT=1560.05n

.meas tran vdout0_30ck1550 FIND v(dout0_30) AT=1560.05n

.meas tran vdout0_31ck1550 FIND v(dout0_31) AT=1560.05n

.meas tran vdout0_32ck1550 FIND v(dout0_32) AT=1560.05n

.meas tran vdout0_0ck1570 FIND v(dout0_0) AT=1580.05n

.meas tran vdout0_1ck1570 FIND v(dout0_1) AT=1580.05n

.meas tran vdout0_2ck1570 FIND v(dout0_2) AT=1580.05n

.meas tran vdout0_3ck1570 FIND v(dout0_3) AT=1580.05n

.meas tran vdout0_4ck1570 FIND v(dout0_4) AT=1580.05n

.meas tran vdout0_5ck1570 FIND v(dout0_5) AT=1580.05n

.meas tran vdout0_6ck1570 FIND v(dout0_6) AT=1580.05n

.meas tran vdout0_7ck1570 FIND v(dout0_7) AT=1580.05n

.meas tran vdout0_8ck1570 FIND v(dout0_8) AT=1580.05n

.meas tran vdout0_9ck1570 FIND v(dout0_9) AT=1580.05n

.meas tran vdout0_10ck1570 FIND v(dout0_10) AT=1580.05n

.meas tran vdout0_11ck1570 FIND v(dout0_11) AT=1580.05n

.meas tran vdout0_12ck1570 FIND v(dout0_12) AT=1580.05n

.meas tran vdout0_13ck1570 FIND v(dout0_13) AT=1580.05n

.meas tran vdout0_14ck1570 FIND v(dout0_14) AT=1580.05n

.meas tran vdout0_15ck1570 FIND v(dout0_15) AT=1580.05n

.meas tran vdout0_16ck1570 FIND v(dout0_16) AT=1580.05n

.meas tran vdout0_17ck1570 FIND v(dout0_17) AT=1580.05n

.meas tran vdout0_18ck1570 FIND v(dout0_18) AT=1580.05n

.meas tran vdout0_19ck1570 FIND v(dout0_19) AT=1580.05n

.meas tran vdout0_20ck1570 FIND v(dout0_20) AT=1580.05n

.meas tran vdout0_21ck1570 FIND v(dout0_21) AT=1580.05n

.meas tran vdout0_22ck1570 FIND v(dout0_22) AT=1580.05n

.meas tran vdout0_23ck1570 FIND v(dout0_23) AT=1580.05n

.meas tran vdout0_24ck1570 FIND v(dout0_24) AT=1580.05n

.meas tran vdout0_25ck1570 FIND v(dout0_25) AT=1580.05n

.meas tran vdout0_26ck1570 FIND v(dout0_26) AT=1580.05n

.meas tran vdout0_27ck1570 FIND v(dout0_27) AT=1580.05n

.meas tran vdout0_28ck1570 FIND v(dout0_28) AT=1580.05n

.meas tran vdout0_29ck1570 FIND v(dout0_29) AT=1580.05n

.meas tran vdout0_30ck1570 FIND v(dout0_30) AT=1580.05n

.meas tran vdout0_31ck1570 FIND v(dout0_31) AT=1580.05n

.meas tran vdout0_32ck1570 FIND v(dout0_32) AT=1580.05n

.meas tran vdout0_0ck1600 FIND v(dout0_0) AT=1610.05n

.meas tran vdout0_1ck1600 FIND v(dout0_1) AT=1610.05n

.meas tran vdout0_2ck1600 FIND v(dout0_2) AT=1610.05n

.meas tran vdout0_3ck1600 FIND v(dout0_3) AT=1610.05n

.meas tran vdout0_4ck1600 FIND v(dout0_4) AT=1610.05n

.meas tran vdout0_5ck1600 FIND v(dout0_5) AT=1610.05n

.meas tran vdout0_6ck1600 FIND v(dout0_6) AT=1610.05n

.meas tran vdout0_7ck1600 FIND v(dout0_7) AT=1610.05n

.meas tran vdout0_8ck1600 FIND v(dout0_8) AT=1610.05n

.meas tran vdout0_9ck1600 FIND v(dout0_9) AT=1610.05n

.meas tran vdout0_10ck1600 FIND v(dout0_10) AT=1610.05n

.meas tran vdout0_11ck1600 FIND v(dout0_11) AT=1610.05n

.meas tran vdout0_12ck1600 FIND v(dout0_12) AT=1610.05n

.meas tran vdout0_13ck1600 FIND v(dout0_13) AT=1610.05n

.meas tran vdout0_14ck1600 FIND v(dout0_14) AT=1610.05n

.meas tran vdout0_15ck1600 FIND v(dout0_15) AT=1610.05n

.meas tran vdout0_16ck1600 FIND v(dout0_16) AT=1610.05n

.meas tran vdout0_17ck1600 FIND v(dout0_17) AT=1610.05n

.meas tran vdout0_18ck1600 FIND v(dout0_18) AT=1610.05n

.meas tran vdout0_19ck1600 FIND v(dout0_19) AT=1610.05n

.meas tran vdout0_20ck1600 FIND v(dout0_20) AT=1610.05n

.meas tran vdout0_21ck1600 FIND v(dout0_21) AT=1610.05n

.meas tran vdout0_22ck1600 FIND v(dout0_22) AT=1610.05n

.meas tran vdout0_23ck1600 FIND v(dout0_23) AT=1610.05n

.meas tran vdout0_24ck1600 FIND v(dout0_24) AT=1610.05n

.meas tran vdout0_25ck1600 FIND v(dout0_25) AT=1610.05n

.meas tran vdout0_26ck1600 FIND v(dout0_26) AT=1610.05n

.meas tran vdout0_27ck1600 FIND v(dout0_27) AT=1610.05n

.meas tran vdout0_28ck1600 FIND v(dout0_28) AT=1610.05n

.meas tran vdout0_29ck1600 FIND v(dout0_29) AT=1610.05n

.meas tran vdout0_30ck1600 FIND v(dout0_30) AT=1610.05n

.meas tran vdout0_31ck1600 FIND v(dout0_31) AT=1610.05n

.meas tran vdout0_32ck1600 FIND v(dout0_32) AT=1610.05n

.meas tran vdout0_0ck1610 FIND v(dout0_0) AT=1620.05n

.meas tran vdout0_1ck1610 FIND v(dout0_1) AT=1620.05n

.meas tran vdout0_2ck1610 FIND v(dout0_2) AT=1620.05n

.meas tran vdout0_3ck1610 FIND v(dout0_3) AT=1620.05n

.meas tran vdout0_4ck1610 FIND v(dout0_4) AT=1620.05n

.meas tran vdout0_5ck1610 FIND v(dout0_5) AT=1620.05n

.meas tran vdout0_6ck1610 FIND v(dout0_6) AT=1620.05n

.meas tran vdout0_7ck1610 FIND v(dout0_7) AT=1620.05n

.meas tran vdout0_8ck1610 FIND v(dout0_8) AT=1620.05n

.meas tran vdout0_9ck1610 FIND v(dout0_9) AT=1620.05n

.meas tran vdout0_10ck1610 FIND v(dout0_10) AT=1620.05n

.meas tran vdout0_11ck1610 FIND v(dout0_11) AT=1620.05n

.meas tran vdout0_12ck1610 FIND v(dout0_12) AT=1620.05n

.meas tran vdout0_13ck1610 FIND v(dout0_13) AT=1620.05n

.meas tran vdout0_14ck1610 FIND v(dout0_14) AT=1620.05n

.meas tran vdout0_15ck1610 FIND v(dout0_15) AT=1620.05n

.meas tran vdout0_16ck1610 FIND v(dout0_16) AT=1620.05n

.meas tran vdout0_17ck1610 FIND v(dout0_17) AT=1620.05n

.meas tran vdout0_18ck1610 FIND v(dout0_18) AT=1620.05n

.meas tran vdout0_19ck1610 FIND v(dout0_19) AT=1620.05n

.meas tran vdout0_20ck1610 FIND v(dout0_20) AT=1620.05n

.meas tran vdout0_21ck1610 FIND v(dout0_21) AT=1620.05n

.meas tran vdout0_22ck1610 FIND v(dout0_22) AT=1620.05n

.meas tran vdout0_23ck1610 FIND v(dout0_23) AT=1620.05n

.meas tran vdout0_24ck1610 FIND v(dout0_24) AT=1620.05n

.meas tran vdout0_25ck1610 FIND v(dout0_25) AT=1620.05n

.meas tran vdout0_26ck1610 FIND v(dout0_26) AT=1620.05n

.meas tran vdout0_27ck1610 FIND v(dout0_27) AT=1620.05n

.meas tran vdout0_28ck1610 FIND v(dout0_28) AT=1620.05n

.meas tran vdout0_29ck1610 FIND v(dout0_29) AT=1620.05n

.meas tran vdout0_30ck1610 FIND v(dout0_30) AT=1620.05n

.meas tran vdout0_31ck1610 FIND v(dout0_31) AT=1620.05n

.meas tran vdout0_32ck1610 FIND v(dout0_32) AT=1620.05n

.meas tran vdout0_0ck1620 FIND v(dout0_0) AT=1630.05n

.meas tran vdout0_1ck1620 FIND v(dout0_1) AT=1630.05n

.meas tran vdout0_2ck1620 FIND v(dout0_2) AT=1630.05n

.meas tran vdout0_3ck1620 FIND v(dout0_3) AT=1630.05n

.meas tran vdout0_4ck1620 FIND v(dout0_4) AT=1630.05n

.meas tran vdout0_5ck1620 FIND v(dout0_5) AT=1630.05n

.meas tran vdout0_6ck1620 FIND v(dout0_6) AT=1630.05n

.meas tran vdout0_7ck1620 FIND v(dout0_7) AT=1630.05n

.meas tran vdout0_8ck1620 FIND v(dout0_8) AT=1630.05n

.meas tran vdout0_9ck1620 FIND v(dout0_9) AT=1630.05n

.meas tran vdout0_10ck1620 FIND v(dout0_10) AT=1630.05n

.meas tran vdout0_11ck1620 FIND v(dout0_11) AT=1630.05n

.meas tran vdout0_12ck1620 FIND v(dout0_12) AT=1630.05n

.meas tran vdout0_13ck1620 FIND v(dout0_13) AT=1630.05n

.meas tran vdout0_14ck1620 FIND v(dout0_14) AT=1630.05n

.meas tran vdout0_15ck1620 FIND v(dout0_15) AT=1630.05n

.meas tran vdout0_16ck1620 FIND v(dout0_16) AT=1630.05n

.meas tran vdout0_17ck1620 FIND v(dout0_17) AT=1630.05n

.meas tran vdout0_18ck1620 FIND v(dout0_18) AT=1630.05n

.meas tran vdout0_19ck1620 FIND v(dout0_19) AT=1630.05n

.meas tran vdout0_20ck1620 FIND v(dout0_20) AT=1630.05n

.meas tran vdout0_21ck1620 FIND v(dout0_21) AT=1630.05n

.meas tran vdout0_22ck1620 FIND v(dout0_22) AT=1630.05n

.meas tran vdout0_23ck1620 FIND v(dout0_23) AT=1630.05n

.meas tran vdout0_24ck1620 FIND v(dout0_24) AT=1630.05n

.meas tran vdout0_25ck1620 FIND v(dout0_25) AT=1630.05n

.meas tran vdout0_26ck1620 FIND v(dout0_26) AT=1630.05n

.meas tran vdout0_27ck1620 FIND v(dout0_27) AT=1630.05n

.meas tran vdout0_28ck1620 FIND v(dout0_28) AT=1630.05n

.meas tran vdout0_29ck1620 FIND v(dout0_29) AT=1630.05n

.meas tran vdout0_30ck1620 FIND v(dout0_30) AT=1630.05n

.meas tran vdout0_31ck1620 FIND v(dout0_31) AT=1630.05n

.meas tran vdout0_32ck1620 FIND v(dout0_32) AT=1630.05n

.meas tran vdout0_0ck1650 FIND v(dout0_0) AT=1660.05n

.meas tran vdout0_1ck1650 FIND v(dout0_1) AT=1660.05n

.meas tran vdout0_2ck1650 FIND v(dout0_2) AT=1660.05n

.meas tran vdout0_3ck1650 FIND v(dout0_3) AT=1660.05n

.meas tran vdout0_4ck1650 FIND v(dout0_4) AT=1660.05n

.meas tran vdout0_5ck1650 FIND v(dout0_5) AT=1660.05n

.meas tran vdout0_6ck1650 FIND v(dout0_6) AT=1660.05n

.meas tran vdout0_7ck1650 FIND v(dout0_7) AT=1660.05n

.meas tran vdout0_8ck1650 FIND v(dout0_8) AT=1660.05n

.meas tran vdout0_9ck1650 FIND v(dout0_9) AT=1660.05n

.meas tran vdout0_10ck1650 FIND v(dout0_10) AT=1660.05n

.meas tran vdout0_11ck1650 FIND v(dout0_11) AT=1660.05n

.meas tran vdout0_12ck1650 FIND v(dout0_12) AT=1660.05n

.meas tran vdout0_13ck1650 FIND v(dout0_13) AT=1660.05n

.meas tran vdout0_14ck1650 FIND v(dout0_14) AT=1660.05n

.meas tran vdout0_15ck1650 FIND v(dout0_15) AT=1660.05n

.meas tran vdout0_16ck1650 FIND v(dout0_16) AT=1660.05n

.meas tran vdout0_17ck1650 FIND v(dout0_17) AT=1660.05n

.meas tran vdout0_18ck1650 FIND v(dout0_18) AT=1660.05n

.meas tran vdout0_19ck1650 FIND v(dout0_19) AT=1660.05n

.meas tran vdout0_20ck1650 FIND v(dout0_20) AT=1660.05n

.meas tran vdout0_21ck1650 FIND v(dout0_21) AT=1660.05n

.meas tran vdout0_22ck1650 FIND v(dout0_22) AT=1660.05n

.meas tran vdout0_23ck1650 FIND v(dout0_23) AT=1660.05n

.meas tran vdout0_24ck1650 FIND v(dout0_24) AT=1660.05n

.meas tran vdout0_25ck1650 FIND v(dout0_25) AT=1660.05n

.meas tran vdout0_26ck1650 FIND v(dout0_26) AT=1660.05n

.meas tran vdout0_27ck1650 FIND v(dout0_27) AT=1660.05n

.meas tran vdout0_28ck1650 FIND v(dout0_28) AT=1660.05n

.meas tran vdout0_29ck1650 FIND v(dout0_29) AT=1660.05n

.meas tran vdout0_30ck1650 FIND v(dout0_30) AT=1660.05n

.meas tran vdout0_31ck1650 FIND v(dout0_31) AT=1660.05n

.meas tran vdout0_32ck1650 FIND v(dout0_32) AT=1660.05n

.meas tran vdout0_0ck1670 FIND v(dout0_0) AT=1680.05n

.meas tran vdout0_1ck1670 FIND v(dout0_1) AT=1680.05n

.meas tran vdout0_2ck1670 FIND v(dout0_2) AT=1680.05n

.meas tran vdout0_3ck1670 FIND v(dout0_3) AT=1680.05n

.meas tran vdout0_4ck1670 FIND v(dout0_4) AT=1680.05n

.meas tran vdout0_5ck1670 FIND v(dout0_5) AT=1680.05n

.meas tran vdout0_6ck1670 FIND v(dout0_6) AT=1680.05n

.meas tran vdout0_7ck1670 FIND v(dout0_7) AT=1680.05n

.meas tran vdout0_8ck1670 FIND v(dout0_8) AT=1680.05n

.meas tran vdout0_9ck1670 FIND v(dout0_9) AT=1680.05n

.meas tran vdout0_10ck1670 FIND v(dout0_10) AT=1680.05n

.meas tran vdout0_11ck1670 FIND v(dout0_11) AT=1680.05n

.meas tran vdout0_12ck1670 FIND v(dout0_12) AT=1680.05n

.meas tran vdout0_13ck1670 FIND v(dout0_13) AT=1680.05n

.meas tran vdout0_14ck1670 FIND v(dout0_14) AT=1680.05n

.meas tran vdout0_15ck1670 FIND v(dout0_15) AT=1680.05n

.meas tran vdout0_16ck1670 FIND v(dout0_16) AT=1680.05n

.meas tran vdout0_17ck1670 FIND v(dout0_17) AT=1680.05n

.meas tran vdout0_18ck1670 FIND v(dout0_18) AT=1680.05n

.meas tran vdout0_19ck1670 FIND v(dout0_19) AT=1680.05n

.meas tran vdout0_20ck1670 FIND v(dout0_20) AT=1680.05n

.meas tran vdout0_21ck1670 FIND v(dout0_21) AT=1680.05n

.meas tran vdout0_22ck1670 FIND v(dout0_22) AT=1680.05n

.meas tran vdout0_23ck1670 FIND v(dout0_23) AT=1680.05n

.meas tran vdout0_24ck1670 FIND v(dout0_24) AT=1680.05n

.meas tran vdout0_25ck1670 FIND v(dout0_25) AT=1680.05n

.meas tran vdout0_26ck1670 FIND v(dout0_26) AT=1680.05n

.meas tran vdout0_27ck1670 FIND v(dout0_27) AT=1680.05n

.meas tran vdout0_28ck1670 FIND v(dout0_28) AT=1680.05n

.meas tran vdout0_29ck1670 FIND v(dout0_29) AT=1680.05n

.meas tran vdout0_30ck1670 FIND v(dout0_30) AT=1680.05n

.meas tran vdout0_31ck1670 FIND v(dout0_31) AT=1680.05n

.meas tran vdout0_32ck1670 FIND v(dout0_32) AT=1680.05n

.meas tran vdout0_0ck1700 FIND v(dout0_0) AT=1710.05n

.meas tran vdout0_1ck1700 FIND v(dout0_1) AT=1710.05n

.meas tran vdout0_2ck1700 FIND v(dout0_2) AT=1710.05n

.meas tran vdout0_3ck1700 FIND v(dout0_3) AT=1710.05n

.meas tran vdout0_4ck1700 FIND v(dout0_4) AT=1710.05n

.meas tran vdout0_5ck1700 FIND v(dout0_5) AT=1710.05n

.meas tran vdout0_6ck1700 FIND v(dout0_6) AT=1710.05n

.meas tran vdout0_7ck1700 FIND v(dout0_7) AT=1710.05n

.meas tran vdout0_8ck1700 FIND v(dout0_8) AT=1710.05n

.meas tran vdout0_9ck1700 FIND v(dout0_9) AT=1710.05n

.meas tran vdout0_10ck1700 FIND v(dout0_10) AT=1710.05n

.meas tran vdout0_11ck1700 FIND v(dout0_11) AT=1710.05n

.meas tran vdout0_12ck1700 FIND v(dout0_12) AT=1710.05n

.meas tran vdout0_13ck1700 FIND v(dout0_13) AT=1710.05n

.meas tran vdout0_14ck1700 FIND v(dout0_14) AT=1710.05n

.meas tran vdout0_15ck1700 FIND v(dout0_15) AT=1710.05n

.meas tran vdout0_16ck1700 FIND v(dout0_16) AT=1710.05n

.meas tran vdout0_17ck1700 FIND v(dout0_17) AT=1710.05n

.meas tran vdout0_18ck1700 FIND v(dout0_18) AT=1710.05n

.meas tran vdout0_19ck1700 FIND v(dout0_19) AT=1710.05n

.meas tran vdout0_20ck1700 FIND v(dout0_20) AT=1710.05n

.meas tran vdout0_21ck1700 FIND v(dout0_21) AT=1710.05n

.meas tran vdout0_22ck1700 FIND v(dout0_22) AT=1710.05n

.meas tran vdout0_23ck1700 FIND v(dout0_23) AT=1710.05n

.meas tran vdout0_24ck1700 FIND v(dout0_24) AT=1710.05n

.meas tran vdout0_25ck1700 FIND v(dout0_25) AT=1710.05n

.meas tran vdout0_26ck1700 FIND v(dout0_26) AT=1710.05n

.meas tran vdout0_27ck1700 FIND v(dout0_27) AT=1710.05n

.meas tran vdout0_28ck1700 FIND v(dout0_28) AT=1710.05n

.meas tran vdout0_29ck1700 FIND v(dout0_29) AT=1710.05n

.meas tran vdout0_30ck1700 FIND v(dout0_30) AT=1710.05n

.meas tran vdout0_31ck1700 FIND v(dout0_31) AT=1710.05n

.meas tran vdout0_32ck1700 FIND v(dout0_32) AT=1710.05n

.meas tran vdout0_0ck1720 FIND v(dout0_0) AT=1730.05n

.meas tran vdout0_1ck1720 FIND v(dout0_1) AT=1730.05n

.meas tran vdout0_2ck1720 FIND v(dout0_2) AT=1730.05n

.meas tran vdout0_3ck1720 FIND v(dout0_3) AT=1730.05n

.meas tran vdout0_4ck1720 FIND v(dout0_4) AT=1730.05n

.meas tran vdout0_5ck1720 FIND v(dout0_5) AT=1730.05n

.meas tran vdout0_6ck1720 FIND v(dout0_6) AT=1730.05n

.meas tran vdout0_7ck1720 FIND v(dout0_7) AT=1730.05n

.meas tran vdout0_8ck1720 FIND v(dout0_8) AT=1730.05n

.meas tran vdout0_9ck1720 FIND v(dout0_9) AT=1730.05n

.meas tran vdout0_10ck1720 FIND v(dout0_10) AT=1730.05n

.meas tran vdout0_11ck1720 FIND v(dout0_11) AT=1730.05n

.meas tran vdout0_12ck1720 FIND v(dout0_12) AT=1730.05n

.meas tran vdout0_13ck1720 FIND v(dout0_13) AT=1730.05n

.meas tran vdout0_14ck1720 FIND v(dout0_14) AT=1730.05n

.meas tran vdout0_15ck1720 FIND v(dout0_15) AT=1730.05n

.meas tran vdout0_16ck1720 FIND v(dout0_16) AT=1730.05n

.meas tran vdout0_17ck1720 FIND v(dout0_17) AT=1730.05n

.meas tran vdout0_18ck1720 FIND v(dout0_18) AT=1730.05n

.meas tran vdout0_19ck1720 FIND v(dout0_19) AT=1730.05n

.meas tran vdout0_20ck1720 FIND v(dout0_20) AT=1730.05n

.meas tran vdout0_21ck1720 FIND v(dout0_21) AT=1730.05n

.meas tran vdout0_22ck1720 FIND v(dout0_22) AT=1730.05n

.meas tran vdout0_23ck1720 FIND v(dout0_23) AT=1730.05n

.meas tran vdout0_24ck1720 FIND v(dout0_24) AT=1730.05n

.meas tran vdout0_25ck1720 FIND v(dout0_25) AT=1730.05n

.meas tran vdout0_26ck1720 FIND v(dout0_26) AT=1730.05n

.meas tran vdout0_27ck1720 FIND v(dout0_27) AT=1730.05n

.meas tran vdout0_28ck1720 FIND v(dout0_28) AT=1730.05n

.meas tran vdout0_29ck1720 FIND v(dout0_29) AT=1730.05n

.meas tran vdout0_30ck1720 FIND v(dout0_30) AT=1730.05n

.meas tran vdout0_31ck1720 FIND v(dout0_31) AT=1730.05n

.meas tran vdout0_32ck1720 FIND v(dout0_32) AT=1730.05n

.meas tran vdout0_0ck1730 FIND v(dout0_0) AT=1740.05n

.meas tran vdout0_1ck1730 FIND v(dout0_1) AT=1740.05n

.meas tran vdout0_2ck1730 FIND v(dout0_2) AT=1740.05n

.meas tran vdout0_3ck1730 FIND v(dout0_3) AT=1740.05n

.meas tran vdout0_4ck1730 FIND v(dout0_4) AT=1740.05n

.meas tran vdout0_5ck1730 FIND v(dout0_5) AT=1740.05n

.meas tran vdout0_6ck1730 FIND v(dout0_6) AT=1740.05n

.meas tran vdout0_7ck1730 FIND v(dout0_7) AT=1740.05n

.meas tran vdout0_8ck1730 FIND v(dout0_8) AT=1740.05n

.meas tran vdout0_9ck1730 FIND v(dout0_9) AT=1740.05n

.meas tran vdout0_10ck1730 FIND v(dout0_10) AT=1740.05n

.meas tran vdout0_11ck1730 FIND v(dout0_11) AT=1740.05n

.meas tran vdout0_12ck1730 FIND v(dout0_12) AT=1740.05n

.meas tran vdout0_13ck1730 FIND v(dout0_13) AT=1740.05n

.meas tran vdout0_14ck1730 FIND v(dout0_14) AT=1740.05n

.meas tran vdout0_15ck1730 FIND v(dout0_15) AT=1740.05n

.meas tran vdout0_16ck1730 FIND v(dout0_16) AT=1740.05n

.meas tran vdout0_17ck1730 FIND v(dout0_17) AT=1740.05n

.meas tran vdout0_18ck1730 FIND v(dout0_18) AT=1740.05n

.meas tran vdout0_19ck1730 FIND v(dout0_19) AT=1740.05n

.meas tran vdout0_20ck1730 FIND v(dout0_20) AT=1740.05n

.meas tran vdout0_21ck1730 FIND v(dout0_21) AT=1740.05n

.meas tran vdout0_22ck1730 FIND v(dout0_22) AT=1740.05n

.meas tran vdout0_23ck1730 FIND v(dout0_23) AT=1740.05n

.meas tran vdout0_24ck1730 FIND v(dout0_24) AT=1740.05n

.meas tran vdout0_25ck1730 FIND v(dout0_25) AT=1740.05n

.meas tran vdout0_26ck1730 FIND v(dout0_26) AT=1740.05n

.meas tran vdout0_27ck1730 FIND v(dout0_27) AT=1740.05n

.meas tran vdout0_28ck1730 FIND v(dout0_28) AT=1740.05n

.meas tran vdout0_29ck1730 FIND v(dout0_29) AT=1740.05n

.meas tran vdout0_30ck1730 FIND v(dout0_30) AT=1740.05n

.meas tran vdout0_31ck1730 FIND v(dout0_31) AT=1740.05n

.meas tran vdout0_32ck1730 FIND v(dout0_32) AT=1740.05n

.meas tran vdout0_0ck1740 FIND v(dout0_0) AT=1750.05n

.meas tran vdout0_1ck1740 FIND v(dout0_1) AT=1750.05n

.meas tran vdout0_2ck1740 FIND v(dout0_2) AT=1750.05n

.meas tran vdout0_3ck1740 FIND v(dout0_3) AT=1750.05n

.meas tran vdout0_4ck1740 FIND v(dout0_4) AT=1750.05n

.meas tran vdout0_5ck1740 FIND v(dout0_5) AT=1750.05n

.meas tran vdout0_6ck1740 FIND v(dout0_6) AT=1750.05n

.meas tran vdout0_7ck1740 FIND v(dout0_7) AT=1750.05n

.meas tran vdout0_8ck1740 FIND v(dout0_8) AT=1750.05n

.meas tran vdout0_9ck1740 FIND v(dout0_9) AT=1750.05n

.meas tran vdout0_10ck1740 FIND v(dout0_10) AT=1750.05n

.meas tran vdout0_11ck1740 FIND v(dout0_11) AT=1750.05n

.meas tran vdout0_12ck1740 FIND v(dout0_12) AT=1750.05n

.meas tran vdout0_13ck1740 FIND v(dout0_13) AT=1750.05n

.meas tran vdout0_14ck1740 FIND v(dout0_14) AT=1750.05n

.meas tran vdout0_15ck1740 FIND v(dout0_15) AT=1750.05n

.meas tran vdout0_16ck1740 FIND v(dout0_16) AT=1750.05n

.meas tran vdout0_17ck1740 FIND v(dout0_17) AT=1750.05n

.meas tran vdout0_18ck1740 FIND v(dout0_18) AT=1750.05n

.meas tran vdout0_19ck1740 FIND v(dout0_19) AT=1750.05n

.meas tran vdout0_20ck1740 FIND v(dout0_20) AT=1750.05n

.meas tran vdout0_21ck1740 FIND v(dout0_21) AT=1750.05n

.meas tran vdout0_22ck1740 FIND v(dout0_22) AT=1750.05n

.meas tran vdout0_23ck1740 FIND v(dout0_23) AT=1750.05n

.meas tran vdout0_24ck1740 FIND v(dout0_24) AT=1750.05n

.meas tran vdout0_25ck1740 FIND v(dout0_25) AT=1750.05n

.meas tran vdout0_26ck1740 FIND v(dout0_26) AT=1750.05n

.meas tran vdout0_27ck1740 FIND v(dout0_27) AT=1750.05n

.meas tran vdout0_28ck1740 FIND v(dout0_28) AT=1750.05n

.meas tran vdout0_29ck1740 FIND v(dout0_29) AT=1750.05n

.meas tran vdout0_30ck1740 FIND v(dout0_30) AT=1750.05n

.meas tran vdout0_31ck1740 FIND v(dout0_31) AT=1750.05n

.meas tran vdout0_32ck1740 FIND v(dout0_32) AT=1750.05n

.meas tran vdout0_0ck1760 FIND v(dout0_0) AT=1770.05n

.meas tran vdout0_1ck1760 FIND v(dout0_1) AT=1770.05n

.meas tran vdout0_2ck1760 FIND v(dout0_2) AT=1770.05n

.meas tran vdout0_3ck1760 FIND v(dout0_3) AT=1770.05n

.meas tran vdout0_4ck1760 FIND v(dout0_4) AT=1770.05n

.meas tran vdout0_5ck1760 FIND v(dout0_5) AT=1770.05n

.meas tran vdout0_6ck1760 FIND v(dout0_6) AT=1770.05n

.meas tran vdout0_7ck1760 FIND v(dout0_7) AT=1770.05n

.meas tran vdout0_8ck1760 FIND v(dout0_8) AT=1770.05n

.meas tran vdout0_9ck1760 FIND v(dout0_9) AT=1770.05n

.meas tran vdout0_10ck1760 FIND v(dout0_10) AT=1770.05n

.meas tran vdout0_11ck1760 FIND v(dout0_11) AT=1770.05n

.meas tran vdout0_12ck1760 FIND v(dout0_12) AT=1770.05n

.meas tran vdout0_13ck1760 FIND v(dout0_13) AT=1770.05n

.meas tran vdout0_14ck1760 FIND v(dout0_14) AT=1770.05n

.meas tran vdout0_15ck1760 FIND v(dout0_15) AT=1770.05n

.meas tran vdout0_16ck1760 FIND v(dout0_16) AT=1770.05n

.meas tran vdout0_17ck1760 FIND v(dout0_17) AT=1770.05n

.meas tran vdout0_18ck1760 FIND v(dout0_18) AT=1770.05n

.meas tran vdout0_19ck1760 FIND v(dout0_19) AT=1770.05n

.meas tran vdout0_20ck1760 FIND v(dout0_20) AT=1770.05n

.meas tran vdout0_21ck1760 FIND v(dout0_21) AT=1770.05n

.meas tran vdout0_22ck1760 FIND v(dout0_22) AT=1770.05n

.meas tran vdout0_23ck1760 FIND v(dout0_23) AT=1770.05n

.meas tran vdout0_24ck1760 FIND v(dout0_24) AT=1770.05n

.meas tran vdout0_25ck1760 FIND v(dout0_25) AT=1770.05n

.meas tran vdout0_26ck1760 FIND v(dout0_26) AT=1770.05n

.meas tran vdout0_27ck1760 FIND v(dout0_27) AT=1770.05n

.meas tran vdout0_28ck1760 FIND v(dout0_28) AT=1770.05n

.meas tran vdout0_29ck1760 FIND v(dout0_29) AT=1770.05n

.meas tran vdout0_30ck1760 FIND v(dout0_30) AT=1770.05n

.meas tran vdout0_31ck1760 FIND v(dout0_31) AT=1770.05n

.meas tran vdout0_32ck1760 FIND v(dout0_32) AT=1770.05n

.meas tran vdout0_0ck1780 FIND v(dout0_0) AT=1790.05n

.meas tran vdout0_1ck1780 FIND v(dout0_1) AT=1790.05n

.meas tran vdout0_2ck1780 FIND v(dout0_2) AT=1790.05n

.meas tran vdout0_3ck1780 FIND v(dout0_3) AT=1790.05n

.meas tran vdout0_4ck1780 FIND v(dout0_4) AT=1790.05n

.meas tran vdout0_5ck1780 FIND v(dout0_5) AT=1790.05n

.meas tran vdout0_6ck1780 FIND v(dout0_6) AT=1790.05n

.meas tran vdout0_7ck1780 FIND v(dout0_7) AT=1790.05n

.meas tran vdout0_8ck1780 FIND v(dout0_8) AT=1790.05n

.meas tran vdout0_9ck1780 FIND v(dout0_9) AT=1790.05n

.meas tran vdout0_10ck1780 FIND v(dout0_10) AT=1790.05n

.meas tran vdout0_11ck1780 FIND v(dout0_11) AT=1790.05n

.meas tran vdout0_12ck1780 FIND v(dout0_12) AT=1790.05n

.meas tran vdout0_13ck1780 FIND v(dout0_13) AT=1790.05n

.meas tran vdout0_14ck1780 FIND v(dout0_14) AT=1790.05n

.meas tran vdout0_15ck1780 FIND v(dout0_15) AT=1790.05n

.meas tran vdout0_16ck1780 FIND v(dout0_16) AT=1790.05n

.meas tran vdout0_17ck1780 FIND v(dout0_17) AT=1790.05n

.meas tran vdout0_18ck1780 FIND v(dout0_18) AT=1790.05n

.meas tran vdout0_19ck1780 FIND v(dout0_19) AT=1790.05n

.meas tran vdout0_20ck1780 FIND v(dout0_20) AT=1790.05n

.meas tran vdout0_21ck1780 FIND v(dout0_21) AT=1790.05n

.meas tran vdout0_22ck1780 FIND v(dout0_22) AT=1790.05n

.meas tran vdout0_23ck1780 FIND v(dout0_23) AT=1790.05n

.meas tran vdout0_24ck1780 FIND v(dout0_24) AT=1790.05n

.meas tran vdout0_25ck1780 FIND v(dout0_25) AT=1790.05n

.meas tran vdout0_26ck1780 FIND v(dout0_26) AT=1790.05n

.meas tran vdout0_27ck1780 FIND v(dout0_27) AT=1790.05n

.meas tran vdout0_28ck1780 FIND v(dout0_28) AT=1790.05n

.meas tran vdout0_29ck1780 FIND v(dout0_29) AT=1790.05n

.meas tran vdout0_30ck1780 FIND v(dout0_30) AT=1790.05n

.meas tran vdout0_31ck1780 FIND v(dout0_31) AT=1790.05n

.meas tran vdout0_32ck1780 FIND v(dout0_32) AT=1790.05n

.meas tran vdout0_0ck1790 FIND v(dout0_0) AT=1800.05n

.meas tran vdout0_1ck1790 FIND v(dout0_1) AT=1800.05n

.meas tran vdout0_2ck1790 FIND v(dout0_2) AT=1800.05n

.meas tran vdout0_3ck1790 FIND v(dout0_3) AT=1800.05n

.meas tran vdout0_4ck1790 FIND v(dout0_4) AT=1800.05n

.meas tran vdout0_5ck1790 FIND v(dout0_5) AT=1800.05n

.meas tran vdout0_6ck1790 FIND v(dout0_6) AT=1800.05n

.meas tran vdout0_7ck1790 FIND v(dout0_7) AT=1800.05n

.meas tran vdout0_8ck1790 FIND v(dout0_8) AT=1800.05n

.meas tran vdout0_9ck1790 FIND v(dout0_9) AT=1800.05n

.meas tran vdout0_10ck1790 FIND v(dout0_10) AT=1800.05n

.meas tran vdout0_11ck1790 FIND v(dout0_11) AT=1800.05n

.meas tran vdout0_12ck1790 FIND v(dout0_12) AT=1800.05n

.meas tran vdout0_13ck1790 FIND v(dout0_13) AT=1800.05n

.meas tran vdout0_14ck1790 FIND v(dout0_14) AT=1800.05n

.meas tran vdout0_15ck1790 FIND v(dout0_15) AT=1800.05n

.meas tran vdout0_16ck1790 FIND v(dout0_16) AT=1800.05n

.meas tran vdout0_17ck1790 FIND v(dout0_17) AT=1800.05n

.meas tran vdout0_18ck1790 FIND v(dout0_18) AT=1800.05n

.meas tran vdout0_19ck1790 FIND v(dout0_19) AT=1800.05n

.meas tran vdout0_20ck1790 FIND v(dout0_20) AT=1800.05n

.meas tran vdout0_21ck1790 FIND v(dout0_21) AT=1800.05n

.meas tran vdout0_22ck1790 FIND v(dout0_22) AT=1800.05n

.meas tran vdout0_23ck1790 FIND v(dout0_23) AT=1800.05n

.meas tran vdout0_24ck1790 FIND v(dout0_24) AT=1800.05n

.meas tran vdout0_25ck1790 FIND v(dout0_25) AT=1800.05n

.meas tran vdout0_26ck1790 FIND v(dout0_26) AT=1800.05n

.meas tran vdout0_27ck1790 FIND v(dout0_27) AT=1800.05n

.meas tran vdout0_28ck1790 FIND v(dout0_28) AT=1800.05n

.meas tran vdout0_29ck1790 FIND v(dout0_29) AT=1800.05n

.meas tran vdout0_30ck1790 FIND v(dout0_30) AT=1800.05n

.meas tran vdout0_31ck1790 FIND v(dout0_31) AT=1800.05n

.meas tran vdout0_32ck1790 FIND v(dout0_32) AT=1800.05n

.meas tran vdout0_0ck1820 FIND v(dout0_0) AT=1830.05n

.meas tran vdout0_1ck1820 FIND v(dout0_1) AT=1830.05n

.meas tran vdout0_2ck1820 FIND v(dout0_2) AT=1830.05n

.meas tran vdout0_3ck1820 FIND v(dout0_3) AT=1830.05n

.meas tran vdout0_4ck1820 FIND v(dout0_4) AT=1830.05n

.meas tran vdout0_5ck1820 FIND v(dout0_5) AT=1830.05n

.meas tran vdout0_6ck1820 FIND v(dout0_6) AT=1830.05n

.meas tran vdout0_7ck1820 FIND v(dout0_7) AT=1830.05n

.meas tran vdout0_8ck1820 FIND v(dout0_8) AT=1830.05n

.meas tran vdout0_9ck1820 FIND v(dout0_9) AT=1830.05n

.meas tran vdout0_10ck1820 FIND v(dout0_10) AT=1830.05n

.meas tran vdout0_11ck1820 FIND v(dout0_11) AT=1830.05n

.meas tran vdout0_12ck1820 FIND v(dout0_12) AT=1830.05n

.meas tran vdout0_13ck1820 FIND v(dout0_13) AT=1830.05n

.meas tran vdout0_14ck1820 FIND v(dout0_14) AT=1830.05n

.meas tran vdout0_15ck1820 FIND v(dout0_15) AT=1830.05n

.meas tran vdout0_16ck1820 FIND v(dout0_16) AT=1830.05n

.meas tran vdout0_17ck1820 FIND v(dout0_17) AT=1830.05n

.meas tran vdout0_18ck1820 FIND v(dout0_18) AT=1830.05n

.meas tran vdout0_19ck1820 FIND v(dout0_19) AT=1830.05n

.meas tran vdout0_20ck1820 FIND v(dout0_20) AT=1830.05n

.meas tran vdout0_21ck1820 FIND v(dout0_21) AT=1830.05n

.meas tran vdout0_22ck1820 FIND v(dout0_22) AT=1830.05n

.meas tran vdout0_23ck1820 FIND v(dout0_23) AT=1830.05n

.meas tran vdout0_24ck1820 FIND v(dout0_24) AT=1830.05n

.meas tran vdout0_25ck1820 FIND v(dout0_25) AT=1830.05n

.meas tran vdout0_26ck1820 FIND v(dout0_26) AT=1830.05n

.meas tran vdout0_27ck1820 FIND v(dout0_27) AT=1830.05n

.meas tran vdout0_28ck1820 FIND v(dout0_28) AT=1830.05n

.meas tran vdout0_29ck1820 FIND v(dout0_29) AT=1830.05n

.meas tran vdout0_30ck1820 FIND v(dout0_30) AT=1830.05n

.meas tran vdout0_31ck1820 FIND v(dout0_31) AT=1830.05n

.meas tran vdout0_32ck1820 FIND v(dout0_32) AT=1830.05n

.meas tran vdout0_0ck1870 FIND v(dout0_0) AT=1880.05n

.meas tran vdout0_1ck1870 FIND v(dout0_1) AT=1880.05n

.meas tran vdout0_2ck1870 FIND v(dout0_2) AT=1880.05n

.meas tran vdout0_3ck1870 FIND v(dout0_3) AT=1880.05n

.meas tran vdout0_4ck1870 FIND v(dout0_4) AT=1880.05n

.meas tran vdout0_5ck1870 FIND v(dout0_5) AT=1880.05n

.meas tran vdout0_6ck1870 FIND v(dout0_6) AT=1880.05n

.meas tran vdout0_7ck1870 FIND v(dout0_7) AT=1880.05n

.meas tran vdout0_8ck1870 FIND v(dout0_8) AT=1880.05n

.meas tran vdout0_9ck1870 FIND v(dout0_9) AT=1880.05n

.meas tran vdout0_10ck1870 FIND v(dout0_10) AT=1880.05n

.meas tran vdout0_11ck1870 FIND v(dout0_11) AT=1880.05n

.meas tran vdout0_12ck1870 FIND v(dout0_12) AT=1880.05n

.meas tran vdout0_13ck1870 FIND v(dout0_13) AT=1880.05n

.meas tran vdout0_14ck1870 FIND v(dout0_14) AT=1880.05n

.meas tran vdout0_15ck1870 FIND v(dout0_15) AT=1880.05n

.meas tran vdout0_16ck1870 FIND v(dout0_16) AT=1880.05n

.meas tran vdout0_17ck1870 FIND v(dout0_17) AT=1880.05n

.meas tran vdout0_18ck1870 FIND v(dout0_18) AT=1880.05n

.meas tran vdout0_19ck1870 FIND v(dout0_19) AT=1880.05n

.meas tran vdout0_20ck1870 FIND v(dout0_20) AT=1880.05n

.meas tran vdout0_21ck1870 FIND v(dout0_21) AT=1880.05n

.meas tran vdout0_22ck1870 FIND v(dout0_22) AT=1880.05n

.meas tran vdout0_23ck1870 FIND v(dout0_23) AT=1880.05n

.meas tran vdout0_24ck1870 FIND v(dout0_24) AT=1880.05n

.meas tran vdout0_25ck1870 FIND v(dout0_25) AT=1880.05n

.meas tran vdout0_26ck1870 FIND v(dout0_26) AT=1880.05n

.meas tran vdout0_27ck1870 FIND v(dout0_27) AT=1880.05n

.meas tran vdout0_28ck1870 FIND v(dout0_28) AT=1880.05n

.meas tran vdout0_29ck1870 FIND v(dout0_29) AT=1880.05n

.meas tran vdout0_30ck1870 FIND v(dout0_30) AT=1880.05n

.meas tran vdout0_31ck1870 FIND v(dout0_31) AT=1880.05n

.meas tran vdout0_32ck1870 FIND v(dout0_32) AT=1880.05n

.meas tran vdout0_0ck1880 FIND v(dout0_0) AT=1890.05n

.meas tran vdout0_1ck1880 FIND v(dout0_1) AT=1890.05n

.meas tran vdout0_2ck1880 FIND v(dout0_2) AT=1890.05n

.meas tran vdout0_3ck1880 FIND v(dout0_3) AT=1890.05n

.meas tran vdout0_4ck1880 FIND v(dout0_4) AT=1890.05n

.meas tran vdout0_5ck1880 FIND v(dout0_5) AT=1890.05n

.meas tran vdout0_6ck1880 FIND v(dout0_6) AT=1890.05n

.meas tran vdout0_7ck1880 FIND v(dout0_7) AT=1890.05n

.meas tran vdout0_8ck1880 FIND v(dout0_8) AT=1890.05n

.meas tran vdout0_9ck1880 FIND v(dout0_9) AT=1890.05n

.meas tran vdout0_10ck1880 FIND v(dout0_10) AT=1890.05n

.meas tran vdout0_11ck1880 FIND v(dout0_11) AT=1890.05n

.meas tran vdout0_12ck1880 FIND v(dout0_12) AT=1890.05n

.meas tran vdout0_13ck1880 FIND v(dout0_13) AT=1890.05n

.meas tran vdout0_14ck1880 FIND v(dout0_14) AT=1890.05n

.meas tran vdout0_15ck1880 FIND v(dout0_15) AT=1890.05n

.meas tran vdout0_16ck1880 FIND v(dout0_16) AT=1890.05n

.meas tran vdout0_17ck1880 FIND v(dout0_17) AT=1890.05n

.meas tran vdout0_18ck1880 FIND v(dout0_18) AT=1890.05n

.meas tran vdout0_19ck1880 FIND v(dout0_19) AT=1890.05n

.meas tran vdout0_20ck1880 FIND v(dout0_20) AT=1890.05n

.meas tran vdout0_21ck1880 FIND v(dout0_21) AT=1890.05n

.meas tran vdout0_22ck1880 FIND v(dout0_22) AT=1890.05n

.meas tran vdout0_23ck1880 FIND v(dout0_23) AT=1890.05n

.meas tran vdout0_24ck1880 FIND v(dout0_24) AT=1890.05n

.meas tran vdout0_25ck1880 FIND v(dout0_25) AT=1890.05n

.meas tran vdout0_26ck1880 FIND v(dout0_26) AT=1890.05n

.meas tran vdout0_27ck1880 FIND v(dout0_27) AT=1890.05n

.meas tran vdout0_28ck1880 FIND v(dout0_28) AT=1890.05n

.meas tran vdout0_29ck1880 FIND v(dout0_29) AT=1890.05n

.meas tran vdout0_30ck1880 FIND v(dout0_30) AT=1890.05n

.meas tran vdout0_31ck1880 FIND v(dout0_31) AT=1890.05n

.meas tran vdout0_32ck1880 FIND v(dout0_32) AT=1890.05n

.meas tran vdout0_0ck1910 FIND v(dout0_0) AT=1920.05n

.meas tran vdout0_1ck1910 FIND v(dout0_1) AT=1920.05n

.meas tran vdout0_2ck1910 FIND v(dout0_2) AT=1920.05n

.meas tran vdout0_3ck1910 FIND v(dout0_3) AT=1920.05n

.meas tran vdout0_4ck1910 FIND v(dout0_4) AT=1920.05n

.meas tran vdout0_5ck1910 FIND v(dout0_5) AT=1920.05n

.meas tran vdout0_6ck1910 FIND v(dout0_6) AT=1920.05n

.meas tran vdout0_7ck1910 FIND v(dout0_7) AT=1920.05n

.meas tran vdout0_8ck1910 FIND v(dout0_8) AT=1920.05n

.meas tran vdout0_9ck1910 FIND v(dout0_9) AT=1920.05n

.meas tran vdout0_10ck1910 FIND v(dout0_10) AT=1920.05n

.meas tran vdout0_11ck1910 FIND v(dout0_11) AT=1920.05n

.meas tran vdout0_12ck1910 FIND v(dout0_12) AT=1920.05n

.meas tran vdout0_13ck1910 FIND v(dout0_13) AT=1920.05n

.meas tran vdout0_14ck1910 FIND v(dout0_14) AT=1920.05n

.meas tran vdout0_15ck1910 FIND v(dout0_15) AT=1920.05n

.meas tran vdout0_16ck1910 FIND v(dout0_16) AT=1920.05n

.meas tran vdout0_17ck1910 FIND v(dout0_17) AT=1920.05n

.meas tran vdout0_18ck1910 FIND v(dout0_18) AT=1920.05n

.meas tran vdout0_19ck1910 FIND v(dout0_19) AT=1920.05n

.meas tran vdout0_20ck1910 FIND v(dout0_20) AT=1920.05n

.meas tran vdout0_21ck1910 FIND v(dout0_21) AT=1920.05n

.meas tran vdout0_22ck1910 FIND v(dout0_22) AT=1920.05n

.meas tran vdout0_23ck1910 FIND v(dout0_23) AT=1920.05n

.meas tran vdout0_24ck1910 FIND v(dout0_24) AT=1920.05n

.meas tran vdout0_25ck1910 FIND v(dout0_25) AT=1920.05n

.meas tran vdout0_26ck1910 FIND v(dout0_26) AT=1920.05n

.meas tran vdout0_27ck1910 FIND v(dout0_27) AT=1920.05n

.meas tran vdout0_28ck1910 FIND v(dout0_28) AT=1920.05n

.meas tran vdout0_29ck1910 FIND v(dout0_29) AT=1920.05n

.meas tran vdout0_30ck1910 FIND v(dout0_30) AT=1920.05n

.meas tran vdout0_31ck1910 FIND v(dout0_31) AT=1920.05n

.meas tran vdout0_32ck1910 FIND v(dout0_32) AT=1920.05n

.meas tran vdout0_0ck1920 FIND v(dout0_0) AT=1930.05n

.meas tran vdout0_1ck1920 FIND v(dout0_1) AT=1930.05n

.meas tran vdout0_2ck1920 FIND v(dout0_2) AT=1930.05n

.meas tran vdout0_3ck1920 FIND v(dout0_3) AT=1930.05n

.meas tran vdout0_4ck1920 FIND v(dout0_4) AT=1930.05n

.meas tran vdout0_5ck1920 FIND v(dout0_5) AT=1930.05n

.meas tran vdout0_6ck1920 FIND v(dout0_6) AT=1930.05n

.meas tran vdout0_7ck1920 FIND v(dout0_7) AT=1930.05n

.meas tran vdout0_8ck1920 FIND v(dout0_8) AT=1930.05n

.meas tran vdout0_9ck1920 FIND v(dout0_9) AT=1930.05n

.meas tran vdout0_10ck1920 FIND v(dout0_10) AT=1930.05n

.meas tran vdout0_11ck1920 FIND v(dout0_11) AT=1930.05n

.meas tran vdout0_12ck1920 FIND v(dout0_12) AT=1930.05n

.meas tran vdout0_13ck1920 FIND v(dout0_13) AT=1930.05n

.meas tran vdout0_14ck1920 FIND v(dout0_14) AT=1930.05n

.meas tran vdout0_15ck1920 FIND v(dout0_15) AT=1930.05n

.meas tran vdout0_16ck1920 FIND v(dout0_16) AT=1930.05n

.meas tran vdout0_17ck1920 FIND v(dout0_17) AT=1930.05n

.meas tran vdout0_18ck1920 FIND v(dout0_18) AT=1930.05n

.meas tran vdout0_19ck1920 FIND v(dout0_19) AT=1930.05n

.meas tran vdout0_20ck1920 FIND v(dout0_20) AT=1930.05n

.meas tran vdout0_21ck1920 FIND v(dout0_21) AT=1930.05n

.meas tran vdout0_22ck1920 FIND v(dout0_22) AT=1930.05n

.meas tran vdout0_23ck1920 FIND v(dout0_23) AT=1930.05n

.meas tran vdout0_24ck1920 FIND v(dout0_24) AT=1930.05n

.meas tran vdout0_25ck1920 FIND v(dout0_25) AT=1930.05n

.meas tran vdout0_26ck1920 FIND v(dout0_26) AT=1930.05n

.meas tran vdout0_27ck1920 FIND v(dout0_27) AT=1930.05n

.meas tran vdout0_28ck1920 FIND v(dout0_28) AT=1930.05n

.meas tran vdout0_29ck1920 FIND v(dout0_29) AT=1930.05n

.meas tran vdout0_30ck1920 FIND v(dout0_30) AT=1930.05n

.meas tran vdout0_31ck1920 FIND v(dout0_31) AT=1930.05n

.meas tran vdout0_32ck1920 FIND v(dout0_32) AT=1930.05n

.meas tran vdout0_0ck1930 FIND v(dout0_0) AT=1940.05n

.meas tran vdout0_1ck1930 FIND v(dout0_1) AT=1940.05n

.meas tran vdout0_2ck1930 FIND v(dout0_2) AT=1940.05n

.meas tran vdout0_3ck1930 FIND v(dout0_3) AT=1940.05n

.meas tran vdout0_4ck1930 FIND v(dout0_4) AT=1940.05n

.meas tran vdout0_5ck1930 FIND v(dout0_5) AT=1940.05n

.meas tran vdout0_6ck1930 FIND v(dout0_6) AT=1940.05n

.meas tran vdout0_7ck1930 FIND v(dout0_7) AT=1940.05n

.meas tran vdout0_8ck1930 FIND v(dout0_8) AT=1940.05n

.meas tran vdout0_9ck1930 FIND v(dout0_9) AT=1940.05n

.meas tran vdout0_10ck1930 FIND v(dout0_10) AT=1940.05n

.meas tran vdout0_11ck1930 FIND v(dout0_11) AT=1940.05n

.meas tran vdout0_12ck1930 FIND v(dout0_12) AT=1940.05n

.meas tran vdout0_13ck1930 FIND v(dout0_13) AT=1940.05n

.meas tran vdout0_14ck1930 FIND v(dout0_14) AT=1940.05n

.meas tran vdout0_15ck1930 FIND v(dout0_15) AT=1940.05n

.meas tran vdout0_16ck1930 FIND v(dout0_16) AT=1940.05n

.meas tran vdout0_17ck1930 FIND v(dout0_17) AT=1940.05n

.meas tran vdout0_18ck1930 FIND v(dout0_18) AT=1940.05n

.meas tran vdout0_19ck1930 FIND v(dout0_19) AT=1940.05n

.meas tran vdout0_20ck1930 FIND v(dout0_20) AT=1940.05n

.meas tran vdout0_21ck1930 FIND v(dout0_21) AT=1940.05n

.meas tran vdout0_22ck1930 FIND v(dout0_22) AT=1940.05n

.meas tran vdout0_23ck1930 FIND v(dout0_23) AT=1940.05n

.meas tran vdout0_24ck1930 FIND v(dout0_24) AT=1940.05n

.meas tran vdout0_25ck1930 FIND v(dout0_25) AT=1940.05n

.meas tran vdout0_26ck1930 FIND v(dout0_26) AT=1940.05n

.meas tran vdout0_27ck1930 FIND v(dout0_27) AT=1940.05n

.meas tran vdout0_28ck1930 FIND v(dout0_28) AT=1940.05n

.meas tran vdout0_29ck1930 FIND v(dout0_29) AT=1940.05n

.meas tran vdout0_30ck1930 FIND v(dout0_30) AT=1940.05n

.meas tran vdout0_31ck1930 FIND v(dout0_31) AT=1940.05n

.meas tran vdout0_32ck1930 FIND v(dout0_32) AT=1940.05n

.meas tran vdout0_0ck1940 FIND v(dout0_0) AT=1950.05n

.meas tran vdout0_1ck1940 FIND v(dout0_1) AT=1950.05n

.meas tran vdout0_2ck1940 FIND v(dout0_2) AT=1950.05n

.meas tran vdout0_3ck1940 FIND v(dout0_3) AT=1950.05n

.meas tran vdout0_4ck1940 FIND v(dout0_4) AT=1950.05n

.meas tran vdout0_5ck1940 FIND v(dout0_5) AT=1950.05n

.meas tran vdout0_6ck1940 FIND v(dout0_6) AT=1950.05n

.meas tran vdout0_7ck1940 FIND v(dout0_7) AT=1950.05n

.meas tran vdout0_8ck1940 FIND v(dout0_8) AT=1950.05n

.meas tran vdout0_9ck1940 FIND v(dout0_9) AT=1950.05n

.meas tran vdout0_10ck1940 FIND v(dout0_10) AT=1950.05n

.meas tran vdout0_11ck1940 FIND v(dout0_11) AT=1950.05n

.meas tran vdout0_12ck1940 FIND v(dout0_12) AT=1950.05n

.meas tran vdout0_13ck1940 FIND v(dout0_13) AT=1950.05n

.meas tran vdout0_14ck1940 FIND v(dout0_14) AT=1950.05n

.meas tran vdout0_15ck1940 FIND v(dout0_15) AT=1950.05n

.meas tran vdout0_16ck1940 FIND v(dout0_16) AT=1950.05n

.meas tran vdout0_17ck1940 FIND v(dout0_17) AT=1950.05n

.meas tran vdout0_18ck1940 FIND v(dout0_18) AT=1950.05n

.meas tran vdout0_19ck1940 FIND v(dout0_19) AT=1950.05n

.meas tran vdout0_20ck1940 FIND v(dout0_20) AT=1950.05n

.meas tran vdout0_21ck1940 FIND v(dout0_21) AT=1950.05n

.meas tran vdout0_22ck1940 FIND v(dout0_22) AT=1950.05n

.meas tran vdout0_23ck1940 FIND v(dout0_23) AT=1950.05n

.meas tran vdout0_24ck1940 FIND v(dout0_24) AT=1950.05n

.meas tran vdout0_25ck1940 FIND v(dout0_25) AT=1950.05n

.meas tran vdout0_26ck1940 FIND v(dout0_26) AT=1950.05n

.meas tran vdout0_27ck1940 FIND v(dout0_27) AT=1950.05n

.meas tran vdout0_28ck1940 FIND v(dout0_28) AT=1950.05n

.meas tran vdout0_29ck1940 FIND v(dout0_29) AT=1950.05n

.meas tran vdout0_30ck1940 FIND v(dout0_30) AT=1950.05n

.meas tran vdout0_31ck1940 FIND v(dout0_31) AT=1950.05n

.meas tran vdout0_32ck1940 FIND v(dout0_32) AT=1950.05n

.meas tran vdout0_0ck1970 FIND v(dout0_0) AT=1980.05n

.meas tran vdout0_1ck1970 FIND v(dout0_1) AT=1980.05n

.meas tran vdout0_2ck1970 FIND v(dout0_2) AT=1980.05n

.meas tran vdout0_3ck1970 FIND v(dout0_3) AT=1980.05n

.meas tran vdout0_4ck1970 FIND v(dout0_4) AT=1980.05n

.meas tran vdout0_5ck1970 FIND v(dout0_5) AT=1980.05n

.meas tran vdout0_6ck1970 FIND v(dout0_6) AT=1980.05n

.meas tran vdout0_7ck1970 FIND v(dout0_7) AT=1980.05n

.meas tran vdout0_8ck1970 FIND v(dout0_8) AT=1980.05n

.meas tran vdout0_9ck1970 FIND v(dout0_9) AT=1980.05n

.meas tran vdout0_10ck1970 FIND v(dout0_10) AT=1980.05n

.meas tran vdout0_11ck1970 FIND v(dout0_11) AT=1980.05n

.meas tran vdout0_12ck1970 FIND v(dout0_12) AT=1980.05n

.meas tran vdout0_13ck1970 FIND v(dout0_13) AT=1980.05n

.meas tran vdout0_14ck1970 FIND v(dout0_14) AT=1980.05n

.meas tran vdout0_15ck1970 FIND v(dout0_15) AT=1980.05n

.meas tran vdout0_16ck1970 FIND v(dout0_16) AT=1980.05n

.meas tran vdout0_17ck1970 FIND v(dout0_17) AT=1980.05n

.meas tran vdout0_18ck1970 FIND v(dout0_18) AT=1980.05n

.meas tran vdout0_19ck1970 FIND v(dout0_19) AT=1980.05n

.meas tran vdout0_20ck1970 FIND v(dout0_20) AT=1980.05n

.meas tran vdout0_21ck1970 FIND v(dout0_21) AT=1980.05n

.meas tran vdout0_22ck1970 FIND v(dout0_22) AT=1980.05n

.meas tran vdout0_23ck1970 FIND v(dout0_23) AT=1980.05n

.meas tran vdout0_24ck1970 FIND v(dout0_24) AT=1980.05n

.meas tran vdout0_25ck1970 FIND v(dout0_25) AT=1980.05n

.meas tran vdout0_26ck1970 FIND v(dout0_26) AT=1980.05n

.meas tran vdout0_27ck1970 FIND v(dout0_27) AT=1980.05n

.meas tran vdout0_28ck1970 FIND v(dout0_28) AT=1980.05n

.meas tran vdout0_29ck1970 FIND v(dout0_29) AT=1980.05n

.meas tran vdout0_30ck1970 FIND v(dout0_30) AT=1980.05n

.meas tran vdout0_31ck1970 FIND v(dout0_31) AT=1980.05n

.meas tran vdout0_32ck1970 FIND v(dout0_32) AT=1980.05n

.meas tran vdout0_0ck1980 FIND v(dout0_0) AT=1990.05n

.meas tran vdout0_1ck1980 FIND v(dout0_1) AT=1990.05n

.meas tran vdout0_2ck1980 FIND v(dout0_2) AT=1990.05n

.meas tran vdout0_3ck1980 FIND v(dout0_3) AT=1990.05n

.meas tran vdout0_4ck1980 FIND v(dout0_4) AT=1990.05n

.meas tran vdout0_5ck1980 FIND v(dout0_5) AT=1990.05n

.meas tran vdout0_6ck1980 FIND v(dout0_6) AT=1990.05n

.meas tran vdout0_7ck1980 FIND v(dout0_7) AT=1990.05n

.meas tran vdout0_8ck1980 FIND v(dout0_8) AT=1990.05n

.meas tran vdout0_9ck1980 FIND v(dout0_9) AT=1990.05n

.meas tran vdout0_10ck1980 FIND v(dout0_10) AT=1990.05n

.meas tran vdout0_11ck1980 FIND v(dout0_11) AT=1990.05n

.meas tran vdout0_12ck1980 FIND v(dout0_12) AT=1990.05n

.meas tran vdout0_13ck1980 FIND v(dout0_13) AT=1990.05n

.meas tran vdout0_14ck1980 FIND v(dout0_14) AT=1990.05n

.meas tran vdout0_15ck1980 FIND v(dout0_15) AT=1990.05n

.meas tran vdout0_16ck1980 FIND v(dout0_16) AT=1990.05n

.meas tran vdout0_17ck1980 FIND v(dout0_17) AT=1990.05n

.meas tran vdout0_18ck1980 FIND v(dout0_18) AT=1990.05n

.meas tran vdout0_19ck1980 FIND v(dout0_19) AT=1990.05n

.meas tran vdout0_20ck1980 FIND v(dout0_20) AT=1990.05n

.meas tran vdout0_21ck1980 FIND v(dout0_21) AT=1990.05n

.meas tran vdout0_22ck1980 FIND v(dout0_22) AT=1990.05n

.meas tran vdout0_23ck1980 FIND v(dout0_23) AT=1990.05n

.meas tran vdout0_24ck1980 FIND v(dout0_24) AT=1990.05n

.meas tran vdout0_25ck1980 FIND v(dout0_25) AT=1990.05n

.meas tran vdout0_26ck1980 FIND v(dout0_26) AT=1990.05n

.meas tran vdout0_27ck1980 FIND v(dout0_27) AT=1990.05n

.meas tran vdout0_28ck1980 FIND v(dout0_28) AT=1990.05n

.meas tran vdout0_29ck1980 FIND v(dout0_29) AT=1990.05n

.meas tran vdout0_30ck1980 FIND v(dout0_30) AT=1990.05n

.meas tran vdout0_31ck1980 FIND v(dout0_31) AT=1990.05n

.meas tran vdout0_32ck1980 FIND v(dout0_32) AT=1990.05n

.meas tran vdout0_0ck2040 FIND v(dout0_0) AT=2050.05n

.meas tran vdout0_1ck2040 FIND v(dout0_1) AT=2050.05n

.meas tran vdout0_2ck2040 FIND v(dout0_2) AT=2050.05n

.meas tran vdout0_3ck2040 FIND v(dout0_3) AT=2050.05n

.meas tran vdout0_4ck2040 FIND v(dout0_4) AT=2050.05n

.meas tran vdout0_5ck2040 FIND v(dout0_5) AT=2050.05n

.meas tran vdout0_6ck2040 FIND v(dout0_6) AT=2050.05n

.meas tran vdout0_7ck2040 FIND v(dout0_7) AT=2050.05n

.meas tran vdout0_8ck2040 FIND v(dout0_8) AT=2050.05n

.meas tran vdout0_9ck2040 FIND v(dout0_9) AT=2050.05n

.meas tran vdout0_10ck2040 FIND v(dout0_10) AT=2050.05n

.meas tran vdout0_11ck2040 FIND v(dout0_11) AT=2050.05n

.meas tran vdout0_12ck2040 FIND v(dout0_12) AT=2050.05n

.meas tran vdout0_13ck2040 FIND v(dout0_13) AT=2050.05n

.meas tran vdout0_14ck2040 FIND v(dout0_14) AT=2050.05n

.meas tran vdout0_15ck2040 FIND v(dout0_15) AT=2050.05n

.meas tran vdout0_16ck2040 FIND v(dout0_16) AT=2050.05n

.meas tran vdout0_17ck2040 FIND v(dout0_17) AT=2050.05n

.meas tran vdout0_18ck2040 FIND v(dout0_18) AT=2050.05n

.meas tran vdout0_19ck2040 FIND v(dout0_19) AT=2050.05n

.meas tran vdout0_20ck2040 FIND v(dout0_20) AT=2050.05n

.meas tran vdout0_21ck2040 FIND v(dout0_21) AT=2050.05n

.meas tran vdout0_22ck2040 FIND v(dout0_22) AT=2050.05n

.meas tran vdout0_23ck2040 FIND v(dout0_23) AT=2050.05n

.meas tran vdout0_24ck2040 FIND v(dout0_24) AT=2050.05n

.meas tran vdout0_25ck2040 FIND v(dout0_25) AT=2050.05n

.meas tran vdout0_26ck2040 FIND v(dout0_26) AT=2050.05n

.meas tran vdout0_27ck2040 FIND v(dout0_27) AT=2050.05n

.meas tran vdout0_28ck2040 FIND v(dout0_28) AT=2050.05n

.meas tran vdout0_29ck2040 FIND v(dout0_29) AT=2050.05n

.meas tran vdout0_30ck2040 FIND v(dout0_30) AT=2050.05n

.meas tran vdout0_31ck2040 FIND v(dout0_31) AT=2050.05n

.meas tran vdout0_32ck2040 FIND v(dout0_32) AT=2050.05n
