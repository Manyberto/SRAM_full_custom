.meas tran vdout0_0ck40 FIND v(dout0_0) AT=50.05n

.meas tran vdout0_1ck40 FIND v(dout0_1) AT=50.05n

.meas tran vdout0_2ck40 FIND v(dout0_2) AT=50.05n

.meas tran vdout0_3ck40 FIND v(dout0_3) AT=50.05n

.meas tran vdout0_4ck40 FIND v(dout0_4) AT=50.05n

.meas tran vdout0_5ck40 FIND v(dout0_5) AT=50.05n

.meas tran vdout0_6ck40 FIND v(dout0_6) AT=50.05n

.meas tran vdout0_7ck40 FIND v(dout0_7) AT=50.05n

.meas tran vdout0_8ck40 FIND v(dout0_8) AT=50.05n

.meas tran vdout0_0ck50 FIND v(dout0_0) AT=60.05n

.meas tran vdout0_1ck50 FIND v(dout0_1) AT=60.05n

.meas tran vdout0_2ck50 FIND v(dout0_2) AT=60.05n

.meas tran vdout0_3ck50 FIND v(dout0_3) AT=60.05n

.meas tran vdout0_4ck50 FIND v(dout0_4) AT=60.05n

.meas tran vdout0_5ck50 FIND v(dout0_5) AT=60.05n

.meas tran vdout0_6ck50 FIND v(dout0_6) AT=60.05n

.meas tran vdout0_7ck50 FIND v(dout0_7) AT=60.05n

.meas tran vdout0_8ck50 FIND v(dout0_8) AT=60.05n

.meas tran vdout0_0ck60 FIND v(dout0_0) AT=70.05n

.meas tran vdout0_1ck60 FIND v(dout0_1) AT=70.05n

.meas tran vdout0_2ck60 FIND v(dout0_2) AT=70.05n

.meas tran vdout0_3ck60 FIND v(dout0_3) AT=70.05n

.meas tran vdout0_4ck60 FIND v(dout0_4) AT=70.05n

.meas tran vdout0_5ck60 FIND v(dout0_5) AT=70.05n

.meas tran vdout0_6ck60 FIND v(dout0_6) AT=70.05n

.meas tran vdout0_7ck60 FIND v(dout0_7) AT=70.05n

.meas tran vdout0_8ck60 FIND v(dout0_8) AT=70.05n

.meas tran vdout0_0ck90 FIND v(dout0_0) AT=100.05n

.meas tran vdout0_1ck90 FIND v(dout0_1) AT=100.05n

.meas tran vdout0_2ck90 FIND v(dout0_2) AT=100.05n

.meas tran vdout0_3ck90 FIND v(dout0_3) AT=100.05n

.meas tran vdout0_4ck90 FIND v(dout0_4) AT=100.05n

.meas tran vdout0_5ck90 FIND v(dout0_5) AT=100.05n

.meas tran vdout0_6ck90 FIND v(dout0_6) AT=100.05n

.meas tran vdout0_7ck90 FIND v(dout0_7) AT=100.05n

.meas tran vdout0_8ck90 FIND v(dout0_8) AT=100.05n

.meas tran vdout0_0ck110 FIND v(dout0_0) AT=120.05n

.meas tran vdout0_1ck110 FIND v(dout0_1) AT=120.05n

.meas tran vdout0_2ck110 FIND v(dout0_2) AT=120.05n

.meas tran vdout0_3ck110 FIND v(dout0_3) AT=120.05n

.meas tran vdout0_4ck110 FIND v(dout0_4) AT=120.05n

.meas tran vdout0_5ck110 FIND v(dout0_5) AT=120.05n

.meas tran vdout0_6ck110 FIND v(dout0_6) AT=120.05n

.meas tran vdout0_7ck110 FIND v(dout0_7) AT=120.05n

.meas tran vdout0_8ck110 FIND v(dout0_8) AT=120.05n

.meas tran vdout0_0ck120 FIND v(dout0_0) AT=130.05n

.meas tran vdout0_1ck120 FIND v(dout0_1) AT=130.05n

.meas tran vdout0_2ck120 FIND v(dout0_2) AT=130.05n

.meas tran vdout0_3ck120 FIND v(dout0_3) AT=130.05n

.meas tran vdout0_4ck120 FIND v(dout0_4) AT=130.05n

.meas tran vdout0_5ck120 FIND v(dout0_5) AT=130.05n

.meas tran vdout0_6ck120 FIND v(dout0_6) AT=130.05n

.meas tran vdout0_7ck120 FIND v(dout0_7) AT=130.05n

.meas tran vdout0_8ck120 FIND v(dout0_8) AT=130.05n

.meas tran vdout0_0ck130 FIND v(dout0_0) AT=140.05n

.meas tran vdout0_1ck130 FIND v(dout0_1) AT=140.05n

.meas tran vdout0_2ck130 FIND v(dout0_2) AT=140.05n

.meas tran vdout0_3ck130 FIND v(dout0_3) AT=140.05n

.meas tran vdout0_4ck130 FIND v(dout0_4) AT=140.05n

.meas tran vdout0_5ck130 FIND v(dout0_5) AT=140.05n

.meas tran vdout0_6ck130 FIND v(dout0_6) AT=140.05n

.meas tran vdout0_7ck130 FIND v(dout0_7) AT=140.05n

.meas tran vdout0_8ck130 FIND v(dout0_8) AT=140.05n

.meas tran vdout0_0ck140 FIND v(dout0_0) AT=150.05n

.meas tran vdout0_1ck140 FIND v(dout0_1) AT=150.05n

.meas tran vdout0_2ck140 FIND v(dout0_2) AT=150.05n

.meas tran vdout0_3ck140 FIND v(dout0_3) AT=150.05n

.meas tran vdout0_4ck140 FIND v(dout0_4) AT=150.05n

.meas tran vdout0_5ck140 FIND v(dout0_5) AT=150.05n

.meas tran vdout0_6ck140 FIND v(dout0_6) AT=150.05n

.meas tran vdout0_7ck140 FIND v(dout0_7) AT=150.05n

.meas tran vdout0_8ck140 FIND v(dout0_8) AT=150.05n

.meas tran vdout0_0ck150 FIND v(dout0_0) AT=160.05n

.meas tran vdout0_1ck150 FIND v(dout0_1) AT=160.05n

.meas tran vdout0_2ck150 FIND v(dout0_2) AT=160.05n

.meas tran vdout0_3ck150 FIND v(dout0_3) AT=160.05n

.meas tran vdout0_4ck150 FIND v(dout0_4) AT=160.05n

.meas tran vdout0_5ck150 FIND v(dout0_5) AT=160.05n

.meas tran vdout0_6ck150 FIND v(dout0_6) AT=160.05n

.meas tran vdout0_7ck150 FIND v(dout0_7) AT=160.05n

.meas tran vdout0_8ck150 FIND v(dout0_8) AT=160.05n

.meas tran vdout0_0ck200 FIND v(dout0_0) AT=210.05n

.meas tran vdout0_1ck200 FIND v(dout0_1) AT=210.05n

.meas tran vdout0_2ck200 FIND v(dout0_2) AT=210.05n

.meas tran vdout0_3ck200 FIND v(dout0_3) AT=210.05n

.meas tran vdout0_4ck200 FIND v(dout0_4) AT=210.05n

.meas tran vdout0_5ck200 FIND v(dout0_5) AT=210.05n

.meas tran vdout0_6ck200 FIND v(dout0_6) AT=210.05n

.meas tran vdout0_7ck200 FIND v(dout0_7) AT=210.05n

.meas tran vdout0_8ck200 FIND v(dout0_8) AT=210.05n

.meas tran vdout0_0ck210 FIND v(dout0_0) AT=220.05n

.meas tran vdout0_1ck210 FIND v(dout0_1) AT=220.05n

.meas tran vdout0_2ck210 FIND v(dout0_2) AT=220.05n

.meas tran vdout0_3ck210 FIND v(dout0_3) AT=220.05n

.meas tran vdout0_4ck210 FIND v(dout0_4) AT=220.05n

.meas tran vdout0_5ck210 FIND v(dout0_5) AT=220.05n

.meas tran vdout0_6ck210 FIND v(dout0_6) AT=220.05n

.meas tran vdout0_7ck210 FIND v(dout0_7) AT=220.05n

.meas tran vdout0_8ck210 FIND v(dout0_8) AT=220.05n

.meas tran vdout0_0ck220 FIND v(dout0_0) AT=230.05n

.meas tran vdout0_1ck220 FIND v(dout0_1) AT=230.05n

.meas tran vdout0_2ck220 FIND v(dout0_2) AT=230.05n

.meas tran vdout0_3ck220 FIND v(dout0_3) AT=230.05n

.meas tran vdout0_4ck220 FIND v(dout0_4) AT=230.05n

.meas tran vdout0_5ck220 FIND v(dout0_5) AT=230.05n

.meas tran vdout0_6ck220 FIND v(dout0_6) AT=230.05n

.meas tran vdout0_7ck220 FIND v(dout0_7) AT=230.05n

.meas tran vdout0_8ck220 FIND v(dout0_8) AT=230.05n

.meas tran vdout0_0ck240 FIND v(dout0_0) AT=250.05n

.meas tran vdout0_1ck240 FIND v(dout0_1) AT=250.05n

.meas tran vdout0_2ck240 FIND v(dout0_2) AT=250.05n

.meas tran vdout0_3ck240 FIND v(dout0_3) AT=250.05n

.meas tran vdout0_4ck240 FIND v(dout0_4) AT=250.05n

.meas tran vdout0_5ck240 FIND v(dout0_5) AT=250.05n

.meas tran vdout0_6ck240 FIND v(dout0_6) AT=250.05n

.meas tran vdout0_7ck240 FIND v(dout0_7) AT=250.05n

.meas tran vdout0_8ck240 FIND v(dout0_8) AT=250.05n

.meas tran vdout0_0ck260 FIND v(dout0_0) AT=270.05n

.meas tran vdout0_1ck260 FIND v(dout0_1) AT=270.05n

.meas tran vdout0_2ck260 FIND v(dout0_2) AT=270.05n

.meas tran vdout0_3ck260 FIND v(dout0_3) AT=270.05n

.meas tran vdout0_4ck260 FIND v(dout0_4) AT=270.05n

.meas tran vdout0_5ck260 FIND v(dout0_5) AT=270.05n

.meas tran vdout0_6ck260 FIND v(dout0_6) AT=270.05n

.meas tran vdout0_7ck260 FIND v(dout0_7) AT=270.05n

.meas tran vdout0_8ck260 FIND v(dout0_8) AT=270.05n

.meas tran vdout0_0ck290 FIND v(dout0_0) AT=300.05n

.meas tran vdout0_1ck290 FIND v(dout0_1) AT=300.05n

.meas tran vdout0_2ck290 FIND v(dout0_2) AT=300.05n

.meas tran vdout0_3ck290 FIND v(dout0_3) AT=300.05n

.meas tran vdout0_4ck290 FIND v(dout0_4) AT=300.05n

.meas tran vdout0_5ck290 FIND v(dout0_5) AT=300.05n

.meas tran vdout0_6ck290 FIND v(dout0_6) AT=300.05n

.meas tran vdout0_7ck290 FIND v(dout0_7) AT=300.05n

.meas tran vdout0_8ck290 FIND v(dout0_8) AT=300.05n

.meas tran vdout0_0ck300 FIND v(dout0_0) AT=310.05n

.meas tran vdout0_1ck300 FIND v(dout0_1) AT=310.05n

.meas tran vdout0_2ck300 FIND v(dout0_2) AT=310.05n

.meas tran vdout0_3ck300 FIND v(dout0_3) AT=310.05n

.meas tran vdout0_4ck300 FIND v(dout0_4) AT=310.05n

.meas tran vdout0_5ck300 FIND v(dout0_5) AT=310.05n

.meas tran vdout0_6ck300 FIND v(dout0_6) AT=310.05n

.meas tran vdout0_7ck300 FIND v(dout0_7) AT=310.05n

.meas tran vdout0_8ck300 FIND v(dout0_8) AT=310.05n

.meas tran vdout0_0ck310 FIND v(dout0_0) AT=320.05n

.meas tran vdout0_1ck310 FIND v(dout0_1) AT=320.05n

.meas tran vdout0_2ck310 FIND v(dout0_2) AT=320.05n

.meas tran vdout0_3ck310 FIND v(dout0_3) AT=320.05n

.meas tran vdout0_4ck310 FIND v(dout0_4) AT=320.05n

.meas tran vdout0_5ck310 FIND v(dout0_5) AT=320.05n

.meas tran vdout0_6ck310 FIND v(dout0_6) AT=320.05n

.meas tran vdout0_7ck310 FIND v(dout0_7) AT=320.05n

.meas tran vdout0_8ck310 FIND v(dout0_8) AT=320.05n

.meas tran vdout0_0ck330 FIND v(dout0_0) AT=340.05n

.meas tran vdout0_1ck330 FIND v(dout0_1) AT=340.05n

.meas tran vdout0_2ck330 FIND v(dout0_2) AT=340.05n

.meas tran vdout0_3ck330 FIND v(dout0_3) AT=340.05n

.meas tran vdout0_4ck330 FIND v(dout0_4) AT=340.05n

.meas tran vdout0_5ck330 FIND v(dout0_5) AT=340.05n

.meas tran vdout0_6ck330 FIND v(dout0_6) AT=340.05n

.meas tran vdout0_7ck330 FIND v(dout0_7) AT=340.05n

.meas tran vdout0_8ck330 FIND v(dout0_8) AT=340.05n

.meas tran vdout0_0ck340 FIND v(dout0_0) AT=350.05n

.meas tran vdout0_1ck340 FIND v(dout0_1) AT=350.05n

.meas tran vdout0_2ck340 FIND v(dout0_2) AT=350.05n

.meas tran vdout0_3ck340 FIND v(dout0_3) AT=350.05n

.meas tran vdout0_4ck340 FIND v(dout0_4) AT=350.05n

.meas tran vdout0_5ck340 FIND v(dout0_5) AT=350.05n

.meas tran vdout0_6ck340 FIND v(dout0_6) AT=350.05n

.meas tran vdout0_7ck340 FIND v(dout0_7) AT=350.05n

.meas tran vdout0_8ck340 FIND v(dout0_8) AT=350.05n

.meas tran vdout0_0ck360 FIND v(dout0_0) AT=370.05n

.meas tran vdout0_1ck360 FIND v(dout0_1) AT=370.05n

.meas tran vdout0_2ck360 FIND v(dout0_2) AT=370.05n

.meas tran vdout0_3ck360 FIND v(dout0_3) AT=370.05n

.meas tran vdout0_4ck360 FIND v(dout0_4) AT=370.05n

.meas tran vdout0_5ck360 FIND v(dout0_5) AT=370.05n

.meas tran vdout0_6ck360 FIND v(dout0_6) AT=370.05n

.meas tran vdout0_7ck360 FIND v(dout0_7) AT=370.05n

.meas tran vdout0_8ck360 FIND v(dout0_8) AT=370.05n

.meas tran vdout0_0ck370 FIND v(dout0_0) AT=380.05n

.meas tran vdout0_1ck370 FIND v(dout0_1) AT=380.05n

.meas tran vdout0_2ck370 FIND v(dout0_2) AT=380.05n

.meas tran vdout0_3ck370 FIND v(dout0_3) AT=380.05n

.meas tran vdout0_4ck370 FIND v(dout0_4) AT=380.05n

.meas tran vdout0_5ck370 FIND v(dout0_5) AT=380.05n

.meas tran vdout0_6ck370 FIND v(dout0_6) AT=380.05n

.meas tran vdout0_7ck370 FIND v(dout0_7) AT=380.05n

.meas tran vdout0_8ck370 FIND v(dout0_8) AT=380.05n

.meas tran vdout0_0ck380 FIND v(dout0_0) AT=390.05n

.meas tran vdout0_1ck380 FIND v(dout0_1) AT=390.05n

.meas tran vdout0_2ck380 FIND v(dout0_2) AT=390.05n

.meas tran vdout0_3ck380 FIND v(dout0_3) AT=390.05n

.meas tran vdout0_4ck380 FIND v(dout0_4) AT=390.05n

.meas tran vdout0_5ck380 FIND v(dout0_5) AT=390.05n

.meas tran vdout0_6ck380 FIND v(dout0_6) AT=390.05n

.meas tran vdout0_7ck380 FIND v(dout0_7) AT=390.05n

.meas tran vdout0_8ck380 FIND v(dout0_8) AT=390.05n

.meas tran vdout0_0ck420 FIND v(dout0_0) AT=430.05n

.meas tran vdout0_1ck420 FIND v(dout0_1) AT=430.05n

.meas tran vdout0_2ck420 FIND v(dout0_2) AT=430.05n

.meas tran vdout0_3ck420 FIND v(dout0_3) AT=430.05n

.meas tran vdout0_4ck420 FIND v(dout0_4) AT=430.05n

.meas tran vdout0_5ck420 FIND v(dout0_5) AT=430.05n

.meas tran vdout0_6ck420 FIND v(dout0_6) AT=430.05n

.meas tran vdout0_7ck420 FIND v(dout0_7) AT=430.05n

.meas tran vdout0_8ck420 FIND v(dout0_8) AT=430.05n

.meas tran vdout0_0ck450 FIND v(dout0_0) AT=460.05n

.meas tran vdout0_1ck450 FIND v(dout0_1) AT=460.05n

.meas tran vdout0_2ck450 FIND v(dout0_2) AT=460.05n

.meas tran vdout0_3ck450 FIND v(dout0_3) AT=460.05n

.meas tran vdout0_4ck450 FIND v(dout0_4) AT=460.05n

.meas tran vdout0_5ck450 FIND v(dout0_5) AT=460.05n

.meas tran vdout0_6ck450 FIND v(dout0_6) AT=460.05n

.meas tran vdout0_7ck450 FIND v(dout0_7) AT=460.05n

.meas tran vdout0_8ck450 FIND v(dout0_8) AT=460.05n

.meas tran vdout0_0ck460 FIND v(dout0_0) AT=470.05n

.meas tran vdout0_1ck460 FIND v(dout0_1) AT=470.05n

.meas tran vdout0_2ck460 FIND v(dout0_2) AT=470.05n

.meas tran vdout0_3ck460 FIND v(dout0_3) AT=470.05n

.meas tran vdout0_4ck460 FIND v(dout0_4) AT=470.05n

.meas tran vdout0_5ck460 FIND v(dout0_5) AT=470.05n

.meas tran vdout0_6ck460 FIND v(dout0_6) AT=470.05n

.meas tran vdout0_7ck460 FIND v(dout0_7) AT=470.05n

.meas tran vdout0_8ck460 FIND v(dout0_8) AT=470.05n

.meas tran vdout0_0ck490 FIND v(dout0_0) AT=500.05n

.meas tran vdout0_1ck490 FIND v(dout0_1) AT=500.05n

.meas tran vdout0_2ck490 FIND v(dout0_2) AT=500.05n

.meas tran vdout0_3ck490 FIND v(dout0_3) AT=500.05n

.meas tran vdout0_4ck490 FIND v(dout0_4) AT=500.05n

.meas tran vdout0_5ck490 FIND v(dout0_5) AT=500.05n

.meas tran vdout0_6ck490 FIND v(dout0_6) AT=500.05n

.meas tran vdout0_7ck490 FIND v(dout0_7) AT=500.05n

.meas tran vdout0_8ck490 FIND v(dout0_8) AT=500.05n

.meas tran vdout0_0ck500 FIND v(dout0_0) AT=510.05n

.meas tran vdout0_1ck500 FIND v(dout0_1) AT=510.05n

.meas tran vdout0_2ck500 FIND v(dout0_2) AT=510.05n

.meas tran vdout0_3ck500 FIND v(dout0_3) AT=510.05n

.meas tran vdout0_4ck500 FIND v(dout0_4) AT=510.05n

.meas tran vdout0_5ck500 FIND v(dout0_5) AT=510.05n

.meas tran vdout0_6ck500 FIND v(dout0_6) AT=510.05n

.meas tran vdout0_7ck500 FIND v(dout0_7) AT=510.05n

.meas tran vdout0_8ck500 FIND v(dout0_8) AT=510.05n

.meas tran vdout0_0ck530 FIND v(dout0_0) AT=540.05n

.meas tran vdout0_1ck530 FIND v(dout0_1) AT=540.05n

.meas tran vdout0_2ck530 FIND v(dout0_2) AT=540.05n

.meas tran vdout0_3ck530 FIND v(dout0_3) AT=540.05n

.meas tran vdout0_4ck530 FIND v(dout0_4) AT=540.05n

.meas tran vdout0_5ck530 FIND v(dout0_5) AT=540.05n

.meas tran vdout0_6ck530 FIND v(dout0_6) AT=540.05n

.meas tran vdout0_7ck530 FIND v(dout0_7) AT=540.05n

.meas tran vdout0_8ck530 FIND v(dout0_8) AT=540.05n

.meas tran vdout0_0ck540 FIND v(dout0_0) AT=550.05n

.meas tran vdout0_1ck540 FIND v(dout0_1) AT=550.05n

.meas tran vdout0_2ck540 FIND v(dout0_2) AT=550.05n

.meas tran vdout0_3ck540 FIND v(dout0_3) AT=550.05n

.meas tran vdout0_4ck540 FIND v(dout0_4) AT=550.05n

.meas tran vdout0_5ck540 FIND v(dout0_5) AT=550.05n

.meas tran vdout0_6ck540 FIND v(dout0_6) AT=550.05n

.meas tran vdout0_7ck540 FIND v(dout0_7) AT=550.05n

.meas tran vdout0_8ck540 FIND v(dout0_8) AT=550.05n

.meas tran vdout0_0ck570 FIND v(dout0_0) AT=580.05n

.meas tran vdout0_1ck570 FIND v(dout0_1) AT=580.05n

.meas tran vdout0_2ck570 FIND v(dout0_2) AT=580.05n

.meas tran vdout0_3ck570 FIND v(dout0_3) AT=580.05n

.meas tran vdout0_4ck570 FIND v(dout0_4) AT=580.05n

.meas tran vdout0_5ck570 FIND v(dout0_5) AT=580.05n

.meas tran vdout0_6ck570 FIND v(dout0_6) AT=580.05n

.meas tran vdout0_7ck570 FIND v(dout0_7) AT=580.05n

.meas tran vdout0_8ck570 FIND v(dout0_8) AT=580.05n

.meas tran vdout0_0ck580 FIND v(dout0_0) AT=590.05n

.meas tran vdout0_1ck580 FIND v(dout0_1) AT=590.05n

.meas tran vdout0_2ck580 FIND v(dout0_2) AT=590.05n

.meas tran vdout0_3ck580 FIND v(dout0_3) AT=590.05n

.meas tran vdout0_4ck580 FIND v(dout0_4) AT=590.05n

.meas tran vdout0_5ck580 FIND v(dout0_5) AT=590.05n

.meas tran vdout0_6ck580 FIND v(dout0_6) AT=590.05n

.meas tran vdout0_7ck580 FIND v(dout0_7) AT=590.05n

.meas tran vdout0_8ck580 FIND v(dout0_8) AT=590.05n

.meas tran vdout0_0ck590 FIND v(dout0_0) AT=600.05n

.meas tran vdout0_1ck590 FIND v(dout0_1) AT=600.05n

.meas tran vdout0_2ck590 FIND v(dout0_2) AT=600.05n

.meas tran vdout0_3ck590 FIND v(dout0_3) AT=600.05n

.meas tran vdout0_4ck590 FIND v(dout0_4) AT=600.05n

.meas tran vdout0_5ck590 FIND v(dout0_5) AT=600.05n

.meas tran vdout0_6ck590 FIND v(dout0_6) AT=600.05n

.meas tran vdout0_7ck590 FIND v(dout0_7) AT=600.05n

.meas tran vdout0_8ck590 FIND v(dout0_8) AT=600.05n

.meas tran vdout0_0ck630 FIND v(dout0_0) AT=640.05n

.meas tran vdout0_1ck630 FIND v(dout0_1) AT=640.05n

.meas tran vdout0_2ck630 FIND v(dout0_2) AT=640.05n

.meas tran vdout0_3ck630 FIND v(dout0_3) AT=640.05n

.meas tran vdout0_4ck630 FIND v(dout0_4) AT=640.05n

.meas tran vdout0_5ck630 FIND v(dout0_5) AT=640.05n

.meas tran vdout0_6ck630 FIND v(dout0_6) AT=640.05n

.meas tran vdout0_7ck630 FIND v(dout0_7) AT=640.05n

.meas tran vdout0_8ck630 FIND v(dout0_8) AT=640.05n

.meas tran vdout0_0ck640 FIND v(dout0_0) AT=650.05n

.meas tran vdout0_1ck640 FIND v(dout0_1) AT=650.05n

.meas tran vdout0_2ck640 FIND v(dout0_2) AT=650.05n

.meas tran vdout0_3ck640 FIND v(dout0_3) AT=650.05n

.meas tran vdout0_4ck640 FIND v(dout0_4) AT=650.05n

.meas tran vdout0_5ck640 FIND v(dout0_5) AT=650.05n

.meas tran vdout0_6ck640 FIND v(dout0_6) AT=650.05n

.meas tran vdout0_7ck640 FIND v(dout0_7) AT=650.05n

.meas tran vdout0_8ck640 FIND v(dout0_8) AT=650.05n

.meas tran vdout0_0ck650 FIND v(dout0_0) AT=660.05n

.meas tran vdout0_1ck650 FIND v(dout0_1) AT=660.05n

.meas tran vdout0_2ck650 FIND v(dout0_2) AT=660.05n

.meas tran vdout0_3ck650 FIND v(dout0_3) AT=660.05n

.meas tran vdout0_4ck650 FIND v(dout0_4) AT=660.05n

.meas tran vdout0_5ck650 FIND v(dout0_5) AT=660.05n

.meas tran vdout0_6ck650 FIND v(dout0_6) AT=660.05n

.meas tran vdout0_7ck650 FIND v(dout0_7) AT=660.05n

.meas tran vdout0_8ck650 FIND v(dout0_8) AT=660.05n

.meas tran vdout0_0ck660 FIND v(dout0_0) AT=670.05n

.meas tran vdout0_1ck660 FIND v(dout0_1) AT=670.05n

.meas tran vdout0_2ck660 FIND v(dout0_2) AT=670.05n

.meas tran vdout0_3ck660 FIND v(dout0_3) AT=670.05n

.meas tran vdout0_4ck660 FIND v(dout0_4) AT=670.05n

.meas tran vdout0_5ck660 FIND v(dout0_5) AT=670.05n

.meas tran vdout0_6ck660 FIND v(dout0_6) AT=670.05n

.meas tran vdout0_7ck660 FIND v(dout0_7) AT=670.05n

.meas tran vdout0_8ck660 FIND v(dout0_8) AT=670.05n

.meas tran vdout0_0ck680 FIND v(dout0_0) AT=690.05n

.meas tran vdout0_1ck680 FIND v(dout0_1) AT=690.05n

.meas tran vdout0_2ck680 FIND v(dout0_2) AT=690.05n

.meas tran vdout0_3ck680 FIND v(dout0_3) AT=690.05n

.meas tran vdout0_4ck680 FIND v(dout0_4) AT=690.05n

.meas tran vdout0_5ck680 FIND v(dout0_5) AT=690.05n

.meas tran vdout0_6ck680 FIND v(dout0_6) AT=690.05n

.meas tran vdout0_7ck680 FIND v(dout0_7) AT=690.05n

.meas tran vdout0_8ck680 FIND v(dout0_8) AT=690.05n

.meas tran vdout0_0ck690 FIND v(dout0_0) AT=700.05n

.meas tran vdout0_1ck690 FIND v(dout0_1) AT=700.05n

.meas tran vdout0_2ck690 FIND v(dout0_2) AT=700.05n

.meas tran vdout0_3ck690 FIND v(dout0_3) AT=700.05n

.meas tran vdout0_4ck690 FIND v(dout0_4) AT=700.05n

.meas tran vdout0_5ck690 FIND v(dout0_5) AT=700.05n

.meas tran vdout0_6ck690 FIND v(dout0_6) AT=700.05n

.meas tran vdout0_7ck690 FIND v(dout0_7) AT=700.05n

.meas tran vdout0_8ck690 FIND v(dout0_8) AT=700.05n

.meas tran vdout0_0ck720 FIND v(dout0_0) AT=730.05n

.meas tran vdout0_1ck720 FIND v(dout0_1) AT=730.05n

.meas tran vdout0_2ck720 FIND v(dout0_2) AT=730.05n

.meas tran vdout0_3ck720 FIND v(dout0_3) AT=730.05n

.meas tran vdout0_4ck720 FIND v(dout0_4) AT=730.05n

.meas tran vdout0_5ck720 FIND v(dout0_5) AT=730.05n

.meas tran vdout0_6ck720 FIND v(dout0_6) AT=730.05n

.meas tran vdout0_7ck720 FIND v(dout0_7) AT=730.05n

.meas tran vdout0_8ck720 FIND v(dout0_8) AT=730.05n

.meas tran vdout0_0ck730 FIND v(dout0_0) AT=740.05n

.meas tran vdout0_1ck730 FIND v(dout0_1) AT=740.05n

.meas tran vdout0_2ck730 FIND v(dout0_2) AT=740.05n

.meas tran vdout0_3ck730 FIND v(dout0_3) AT=740.05n

.meas tran vdout0_4ck730 FIND v(dout0_4) AT=740.05n

.meas tran vdout0_5ck730 FIND v(dout0_5) AT=740.05n

.meas tran vdout0_6ck730 FIND v(dout0_6) AT=740.05n

.meas tran vdout0_7ck730 FIND v(dout0_7) AT=740.05n

.meas tran vdout0_8ck730 FIND v(dout0_8) AT=740.05n

.meas tran vdout0_0ck740 FIND v(dout0_0) AT=750.05n

.meas tran vdout0_1ck740 FIND v(dout0_1) AT=750.05n

.meas tran vdout0_2ck740 FIND v(dout0_2) AT=750.05n

.meas tran vdout0_3ck740 FIND v(dout0_3) AT=750.05n

.meas tran vdout0_4ck740 FIND v(dout0_4) AT=750.05n

.meas tran vdout0_5ck740 FIND v(dout0_5) AT=750.05n

.meas tran vdout0_6ck740 FIND v(dout0_6) AT=750.05n

.meas tran vdout0_7ck740 FIND v(dout0_7) AT=750.05n

.meas tran vdout0_8ck740 FIND v(dout0_8) AT=750.05n

.meas tran vdout0_0ck770 FIND v(dout0_0) AT=780.05n

.meas tran vdout0_1ck770 FIND v(dout0_1) AT=780.05n

.meas tran vdout0_2ck770 FIND v(dout0_2) AT=780.05n

.meas tran vdout0_3ck770 FIND v(dout0_3) AT=780.05n

.meas tran vdout0_4ck770 FIND v(dout0_4) AT=780.05n

.meas tran vdout0_5ck770 FIND v(dout0_5) AT=780.05n

.meas tran vdout0_6ck770 FIND v(dout0_6) AT=780.05n

.meas tran vdout0_7ck770 FIND v(dout0_7) AT=780.05n

.meas tran vdout0_8ck770 FIND v(dout0_8) AT=780.05n

.meas tran vdout0_0ck780 FIND v(dout0_0) AT=790.05n

.meas tran vdout0_1ck780 FIND v(dout0_1) AT=790.05n

.meas tran vdout0_2ck780 FIND v(dout0_2) AT=790.05n

.meas tran vdout0_3ck780 FIND v(dout0_3) AT=790.05n

.meas tran vdout0_4ck780 FIND v(dout0_4) AT=790.05n

.meas tran vdout0_5ck780 FIND v(dout0_5) AT=790.05n

.meas tran vdout0_6ck780 FIND v(dout0_6) AT=790.05n

.meas tran vdout0_7ck780 FIND v(dout0_7) AT=790.05n

.meas tran vdout0_8ck780 FIND v(dout0_8) AT=790.05n

.meas tran vdout0_0ck800 FIND v(dout0_0) AT=810.05n

.meas tran vdout0_1ck800 FIND v(dout0_1) AT=810.05n

.meas tran vdout0_2ck800 FIND v(dout0_2) AT=810.05n

.meas tran vdout0_3ck800 FIND v(dout0_3) AT=810.05n

.meas tran vdout0_4ck800 FIND v(dout0_4) AT=810.05n

.meas tran vdout0_5ck800 FIND v(dout0_5) AT=810.05n

.meas tran vdout0_6ck800 FIND v(dout0_6) AT=810.05n

.meas tran vdout0_7ck800 FIND v(dout0_7) AT=810.05n

.meas tran vdout0_8ck800 FIND v(dout0_8) AT=810.05n

.meas tran vdout0_0ck810 FIND v(dout0_0) AT=820.05n

.meas tran vdout0_1ck810 FIND v(dout0_1) AT=820.05n

.meas tran vdout0_2ck810 FIND v(dout0_2) AT=820.05n

.meas tran vdout0_3ck810 FIND v(dout0_3) AT=820.05n

.meas tran vdout0_4ck810 FIND v(dout0_4) AT=820.05n

.meas tran vdout0_5ck810 FIND v(dout0_5) AT=820.05n

.meas tran vdout0_6ck810 FIND v(dout0_6) AT=820.05n

.meas tran vdout0_7ck810 FIND v(dout0_7) AT=820.05n

.meas tran vdout0_8ck810 FIND v(dout0_8) AT=820.05n

.meas tran vdout0_0ck910 FIND v(dout0_0) AT=920.05n

.meas tran vdout0_1ck910 FIND v(dout0_1) AT=920.05n

.meas tran vdout0_2ck910 FIND v(dout0_2) AT=920.05n

.meas tran vdout0_3ck910 FIND v(dout0_3) AT=920.05n

.meas tran vdout0_4ck910 FIND v(dout0_4) AT=920.05n

.meas tran vdout0_5ck910 FIND v(dout0_5) AT=920.05n

.meas tran vdout0_6ck910 FIND v(dout0_6) AT=920.05n

.meas tran vdout0_7ck910 FIND v(dout0_7) AT=920.05n

.meas tran vdout0_8ck910 FIND v(dout0_8) AT=920.05n

.meas tran vdout0_0ck970 FIND v(dout0_0) AT=980.05n

.meas tran vdout0_1ck970 FIND v(dout0_1) AT=980.05n

.meas tran vdout0_2ck970 FIND v(dout0_2) AT=980.05n

.meas tran vdout0_3ck970 FIND v(dout0_3) AT=980.05n

.meas tran vdout0_4ck970 FIND v(dout0_4) AT=980.05n

.meas tran vdout0_5ck970 FIND v(dout0_5) AT=980.05n

.meas tran vdout0_6ck970 FIND v(dout0_6) AT=980.05n

.meas tran vdout0_7ck970 FIND v(dout0_7) AT=980.05n

.meas tran vdout0_8ck970 FIND v(dout0_8) AT=980.05n

.meas tran vdout0_0ck1000 FIND v(dout0_0) AT=1010.05n

.meas tran vdout0_1ck1000 FIND v(dout0_1) AT=1010.05n

.meas tran vdout0_2ck1000 FIND v(dout0_2) AT=1010.05n

.meas tran vdout0_3ck1000 FIND v(dout0_3) AT=1010.05n

.meas tran vdout0_4ck1000 FIND v(dout0_4) AT=1010.05n

.meas tran vdout0_5ck1000 FIND v(dout0_5) AT=1010.05n

.meas tran vdout0_6ck1000 FIND v(dout0_6) AT=1010.05n

.meas tran vdout0_7ck1000 FIND v(dout0_7) AT=1010.05n

.meas tran vdout0_8ck1000 FIND v(dout0_8) AT=1010.05n

.meas tran vdout0_0ck1010 FIND v(dout0_0) AT=1020.05n

.meas tran vdout0_1ck1010 FIND v(dout0_1) AT=1020.05n

.meas tran vdout0_2ck1010 FIND v(dout0_2) AT=1020.05n

.meas tran vdout0_3ck1010 FIND v(dout0_3) AT=1020.05n

.meas tran vdout0_4ck1010 FIND v(dout0_4) AT=1020.05n

.meas tran vdout0_5ck1010 FIND v(dout0_5) AT=1020.05n

.meas tran vdout0_6ck1010 FIND v(dout0_6) AT=1020.05n

.meas tran vdout0_7ck1010 FIND v(dout0_7) AT=1020.05n

.meas tran vdout0_8ck1010 FIND v(dout0_8) AT=1020.05n

.meas tran vdout0_0ck1030 FIND v(dout0_0) AT=1040.05n

.meas tran vdout0_1ck1030 FIND v(dout0_1) AT=1040.05n

.meas tran vdout0_2ck1030 FIND v(dout0_2) AT=1040.05n

.meas tran vdout0_3ck1030 FIND v(dout0_3) AT=1040.05n

.meas tran vdout0_4ck1030 FIND v(dout0_4) AT=1040.05n

.meas tran vdout0_5ck1030 FIND v(dout0_5) AT=1040.05n

.meas tran vdout0_6ck1030 FIND v(dout0_6) AT=1040.05n

.meas tran vdout0_7ck1030 FIND v(dout0_7) AT=1040.05n

.meas tran vdout0_8ck1030 FIND v(dout0_8) AT=1040.05n

.meas tran vdout0_0ck1040 FIND v(dout0_0) AT=1050.05n

.meas tran vdout0_1ck1040 FIND v(dout0_1) AT=1050.05n

.meas tran vdout0_2ck1040 FIND v(dout0_2) AT=1050.05n

.meas tran vdout0_3ck1040 FIND v(dout0_3) AT=1050.05n

.meas tran vdout0_4ck1040 FIND v(dout0_4) AT=1050.05n

.meas tran vdout0_5ck1040 FIND v(dout0_5) AT=1050.05n

.meas tran vdout0_6ck1040 FIND v(dout0_6) AT=1050.05n

.meas tran vdout0_7ck1040 FIND v(dout0_7) AT=1050.05n

.meas tran vdout0_8ck1040 FIND v(dout0_8) AT=1050.05n

.meas tran vdout0_0ck1060 FIND v(dout0_0) AT=1070.05n

.meas tran vdout0_1ck1060 FIND v(dout0_1) AT=1070.05n

.meas tran vdout0_2ck1060 FIND v(dout0_2) AT=1070.05n

.meas tran vdout0_3ck1060 FIND v(dout0_3) AT=1070.05n

.meas tran vdout0_4ck1060 FIND v(dout0_4) AT=1070.05n

.meas tran vdout0_5ck1060 FIND v(dout0_5) AT=1070.05n

.meas tran vdout0_6ck1060 FIND v(dout0_6) AT=1070.05n

.meas tran vdout0_7ck1060 FIND v(dout0_7) AT=1070.05n

.meas tran vdout0_8ck1060 FIND v(dout0_8) AT=1070.05n

.meas tran vdout0_0ck1070 FIND v(dout0_0) AT=1080.05n

.meas tran vdout0_1ck1070 FIND v(dout0_1) AT=1080.05n

.meas tran vdout0_2ck1070 FIND v(dout0_2) AT=1080.05n

.meas tran vdout0_3ck1070 FIND v(dout0_3) AT=1080.05n

.meas tran vdout0_4ck1070 FIND v(dout0_4) AT=1080.05n

.meas tran vdout0_5ck1070 FIND v(dout0_5) AT=1080.05n

.meas tran vdout0_6ck1070 FIND v(dout0_6) AT=1080.05n

.meas tran vdout0_7ck1070 FIND v(dout0_7) AT=1080.05n

.meas tran vdout0_8ck1070 FIND v(dout0_8) AT=1080.05n

.meas tran vdout0_0ck1090 FIND v(dout0_0) AT=1100.05n

.meas tran vdout0_1ck1090 FIND v(dout0_1) AT=1100.05n

.meas tran vdout0_2ck1090 FIND v(dout0_2) AT=1100.05n

.meas tran vdout0_3ck1090 FIND v(dout0_3) AT=1100.05n

.meas tran vdout0_4ck1090 FIND v(dout0_4) AT=1100.05n

.meas tran vdout0_5ck1090 FIND v(dout0_5) AT=1100.05n

.meas tran vdout0_6ck1090 FIND v(dout0_6) AT=1100.05n

.meas tran vdout0_7ck1090 FIND v(dout0_7) AT=1100.05n

.meas tran vdout0_8ck1090 FIND v(dout0_8) AT=1100.05n

.meas tran vdout0_0ck1100 FIND v(dout0_0) AT=1110.05n

.meas tran vdout0_1ck1100 FIND v(dout0_1) AT=1110.05n

.meas tran vdout0_2ck1100 FIND v(dout0_2) AT=1110.05n

.meas tran vdout0_3ck1100 FIND v(dout0_3) AT=1110.05n

.meas tran vdout0_4ck1100 FIND v(dout0_4) AT=1110.05n

.meas tran vdout0_5ck1100 FIND v(dout0_5) AT=1110.05n

.meas tran vdout0_6ck1100 FIND v(dout0_6) AT=1110.05n

.meas tran vdout0_7ck1100 FIND v(dout0_7) AT=1110.05n

.meas tran vdout0_8ck1100 FIND v(dout0_8) AT=1110.05n

.meas tran vdout0_0ck1110 FIND v(dout0_0) AT=1120.05n

.meas tran vdout0_1ck1110 FIND v(dout0_1) AT=1120.05n

.meas tran vdout0_2ck1110 FIND v(dout0_2) AT=1120.05n

.meas tran vdout0_3ck1110 FIND v(dout0_3) AT=1120.05n

.meas tran vdout0_4ck1110 FIND v(dout0_4) AT=1120.05n

.meas tran vdout0_5ck1110 FIND v(dout0_5) AT=1120.05n

.meas tran vdout0_6ck1110 FIND v(dout0_6) AT=1120.05n

.meas tran vdout0_7ck1110 FIND v(dout0_7) AT=1120.05n

.meas tran vdout0_8ck1110 FIND v(dout0_8) AT=1120.05n

.meas tran vdout0_0ck1120 FIND v(dout0_0) AT=1130.05n

.meas tran vdout0_1ck1120 FIND v(dout0_1) AT=1130.05n

.meas tran vdout0_2ck1120 FIND v(dout0_2) AT=1130.05n

.meas tran vdout0_3ck1120 FIND v(dout0_3) AT=1130.05n

.meas tran vdout0_4ck1120 FIND v(dout0_4) AT=1130.05n

.meas tran vdout0_5ck1120 FIND v(dout0_5) AT=1130.05n

.meas tran vdout0_6ck1120 FIND v(dout0_6) AT=1130.05n

.meas tran vdout0_7ck1120 FIND v(dout0_7) AT=1130.05n

.meas tran vdout0_8ck1120 FIND v(dout0_8) AT=1130.05n

.meas tran vdout0_0ck1170 FIND v(dout0_0) AT=1180.05n

.meas tran vdout0_1ck1170 FIND v(dout0_1) AT=1180.05n

.meas tran vdout0_2ck1170 FIND v(dout0_2) AT=1180.05n

.meas tran vdout0_3ck1170 FIND v(dout0_3) AT=1180.05n

.meas tran vdout0_4ck1170 FIND v(dout0_4) AT=1180.05n

.meas tran vdout0_5ck1170 FIND v(dout0_5) AT=1180.05n

.meas tran vdout0_6ck1170 FIND v(dout0_6) AT=1180.05n

.meas tran vdout0_7ck1170 FIND v(dout0_7) AT=1180.05n

.meas tran vdout0_8ck1170 FIND v(dout0_8) AT=1180.05n

.meas tran vdout0_0ck1220 FIND v(dout0_0) AT=1230.05n

.meas tran vdout0_1ck1220 FIND v(dout0_1) AT=1230.05n

.meas tran vdout0_2ck1220 FIND v(dout0_2) AT=1230.05n

.meas tran vdout0_3ck1220 FIND v(dout0_3) AT=1230.05n

.meas tran vdout0_4ck1220 FIND v(dout0_4) AT=1230.05n

.meas tran vdout0_5ck1220 FIND v(dout0_5) AT=1230.05n

.meas tran vdout0_6ck1220 FIND v(dout0_6) AT=1230.05n

.meas tran vdout0_7ck1220 FIND v(dout0_7) AT=1230.05n

.meas tran vdout0_8ck1220 FIND v(dout0_8) AT=1230.05n

.meas tran vdout0_0ck1230 FIND v(dout0_0) AT=1240.05n

.meas tran vdout0_1ck1230 FIND v(dout0_1) AT=1240.05n

.meas tran vdout0_2ck1230 FIND v(dout0_2) AT=1240.05n

.meas tran vdout0_3ck1230 FIND v(dout0_3) AT=1240.05n

.meas tran vdout0_4ck1230 FIND v(dout0_4) AT=1240.05n

.meas tran vdout0_5ck1230 FIND v(dout0_5) AT=1240.05n

.meas tran vdout0_6ck1230 FIND v(dout0_6) AT=1240.05n

.meas tran vdout0_7ck1230 FIND v(dout0_7) AT=1240.05n

.meas tran vdout0_8ck1230 FIND v(dout0_8) AT=1240.05n

.meas tran vdout0_0ck1240 FIND v(dout0_0) AT=1250.05n

.meas tran vdout0_1ck1240 FIND v(dout0_1) AT=1250.05n

.meas tran vdout0_2ck1240 FIND v(dout0_2) AT=1250.05n

.meas tran vdout0_3ck1240 FIND v(dout0_3) AT=1250.05n

.meas tran vdout0_4ck1240 FIND v(dout0_4) AT=1250.05n

.meas tran vdout0_5ck1240 FIND v(dout0_5) AT=1250.05n

.meas tran vdout0_6ck1240 FIND v(dout0_6) AT=1250.05n

.meas tran vdout0_7ck1240 FIND v(dout0_7) AT=1250.05n

.meas tran vdout0_8ck1240 FIND v(dout0_8) AT=1250.05n

.meas tran vdout0_0ck1250 FIND v(dout0_0) AT=1260.05n

.meas tran vdout0_1ck1250 FIND v(dout0_1) AT=1260.05n

.meas tran vdout0_2ck1250 FIND v(dout0_2) AT=1260.05n

.meas tran vdout0_3ck1250 FIND v(dout0_3) AT=1260.05n

.meas tran vdout0_4ck1250 FIND v(dout0_4) AT=1260.05n

.meas tran vdout0_5ck1250 FIND v(dout0_5) AT=1260.05n

.meas tran vdout0_6ck1250 FIND v(dout0_6) AT=1260.05n

.meas tran vdout0_7ck1250 FIND v(dout0_7) AT=1260.05n

.meas tran vdout0_8ck1250 FIND v(dout0_8) AT=1260.05n

.meas tran vdout0_0ck1270 FIND v(dout0_0) AT=1280.05n

.meas tran vdout0_1ck1270 FIND v(dout0_1) AT=1280.05n

.meas tran vdout0_2ck1270 FIND v(dout0_2) AT=1280.05n

.meas tran vdout0_3ck1270 FIND v(dout0_3) AT=1280.05n

.meas tran vdout0_4ck1270 FIND v(dout0_4) AT=1280.05n

.meas tran vdout0_5ck1270 FIND v(dout0_5) AT=1280.05n

.meas tran vdout0_6ck1270 FIND v(dout0_6) AT=1280.05n

.meas tran vdout0_7ck1270 FIND v(dout0_7) AT=1280.05n

.meas tran vdout0_8ck1270 FIND v(dout0_8) AT=1280.05n

.meas tran vdout0_0ck1290 FIND v(dout0_0) AT=1300.05n

.meas tran vdout0_1ck1290 FIND v(dout0_1) AT=1300.05n

.meas tran vdout0_2ck1290 FIND v(dout0_2) AT=1300.05n

.meas tran vdout0_3ck1290 FIND v(dout0_3) AT=1300.05n

.meas tran vdout0_4ck1290 FIND v(dout0_4) AT=1300.05n

.meas tran vdout0_5ck1290 FIND v(dout0_5) AT=1300.05n

.meas tran vdout0_6ck1290 FIND v(dout0_6) AT=1300.05n

.meas tran vdout0_7ck1290 FIND v(dout0_7) AT=1300.05n

.meas tran vdout0_8ck1290 FIND v(dout0_8) AT=1300.05n

.meas tran vdout0_0ck1330 FIND v(dout0_0) AT=1340.05n

.meas tran vdout0_1ck1330 FIND v(dout0_1) AT=1340.05n

.meas tran vdout0_2ck1330 FIND v(dout0_2) AT=1340.05n

.meas tran vdout0_3ck1330 FIND v(dout0_3) AT=1340.05n

.meas tran vdout0_4ck1330 FIND v(dout0_4) AT=1340.05n

.meas tran vdout0_5ck1330 FIND v(dout0_5) AT=1340.05n

.meas tran vdout0_6ck1330 FIND v(dout0_6) AT=1340.05n

.meas tran vdout0_7ck1330 FIND v(dout0_7) AT=1340.05n

.meas tran vdout0_8ck1330 FIND v(dout0_8) AT=1340.05n

.meas tran vdout0_0ck1350 FIND v(dout0_0) AT=1360.05n

.meas tran vdout0_1ck1350 FIND v(dout0_1) AT=1360.05n

.meas tran vdout0_2ck1350 FIND v(dout0_2) AT=1360.05n

.meas tran vdout0_3ck1350 FIND v(dout0_3) AT=1360.05n

.meas tran vdout0_4ck1350 FIND v(dout0_4) AT=1360.05n

.meas tran vdout0_5ck1350 FIND v(dout0_5) AT=1360.05n

.meas tran vdout0_6ck1350 FIND v(dout0_6) AT=1360.05n

.meas tran vdout0_7ck1350 FIND v(dout0_7) AT=1360.05n

.meas tran vdout0_8ck1350 FIND v(dout0_8) AT=1360.05n

.meas tran vdout0_0ck1370 FIND v(dout0_0) AT=1380.05n

.meas tran vdout0_1ck1370 FIND v(dout0_1) AT=1380.05n

.meas tran vdout0_2ck1370 FIND v(dout0_2) AT=1380.05n

.meas tran vdout0_3ck1370 FIND v(dout0_3) AT=1380.05n

.meas tran vdout0_4ck1370 FIND v(dout0_4) AT=1380.05n

.meas tran vdout0_5ck1370 FIND v(dout0_5) AT=1380.05n

.meas tran vdout0_6ck1370 FIND v(dout0_6) AT=1380.05n

.meas tran vdout0_7ck1370 FIND v(dout0_7) AT=1380.05n

.meas tran vdout0_8ck1370 FIND v(dout0_8) AT=1380.05n

.meas tran vdout0_0ck1410 FIND v(dout0_0) AT=1420.05n

.meas tran vdout0_1ck1410 FIND v(dout0_1) AT=1420.05n

.meas tran vdout0_2ck1410 FIND v(dout0_2) AT=1420.05n

.meas tran vdout0_3ck1410 FIND v(dout0_3) AT=1420.05n

.meas tran vdout0_4ck1410 FIND v(dout0_4) AT=1420.05n

.meas tran vdout0_5ck1410 FIND v(dout0_5) AT=1420.05n

.meas tran vdout0_6ck1410 FIND v(dout0_6) AT=1420.05n

.meas tran vdout0_7ck1410 FIND v(dout0_7) AT=1420.05n

.meas tran vdout0_8ck1410 FIND v(dout0_8) AT=1420.05n

.meas tran vdout0_0ck1430 FIND v(dout0_0) AT=1440.05n

.meas tran vdout0_1ck1430 FIND v(dout0_1) AT=1440.05n

.meas tran vdout0_2ck1430 FIND v(dout0_2) AT=1440.05n

.meas tran vdout0_3ck1430 FIND v(dout0_3) AT=1440.05n

.meas tran vdout0_4ck1430 FIND v(dout0_4) AT=1440.05n

.meas tran vdout0_5ck1430 FIND v(dout0_5) AT=1440.05n

.meas tran vdout0_6ck1430 FIND v(dout0_6) AT=1440.05n

.meas tran vdout0_7ck1430 FIND v(dout0_7) AT=1440.05n

.meas tran vdout0_8ck1430 FIND v(dout0_8) AT=1440.05n

.meas tran vdout0_0ck1450 FIND v(dout0_0) AT=1460.05n

.meas tran vdout0_1ck1450 FIND v(dout0_1) AT=1460.05n

.meas tran vdout0_2ck1450 FIND v(dout0_2) AT=1460.05n

.meas tran vdout0_3ck1450 FIND v(dout0_3) AT=1460.05n

.meas tran vdout0_4ck1450 FIND v(dout0_4) AT=1460.05n

.meas tran vdout0_5ck1450 FIND v(dout0_5) AT=1460.05n

.meas tran vdout0_6ck1450 FIND v(dout0_6) AT=1460.05n

.meas tran vdout0_7ck1450 FIND v(dout0_7) AT=1460.05n

.meas tran vdout0_8ck1450 FIND v(dout0_8) AT=1460.05n

.meas tran vdout0_0ck1460 FIND v(dout0_0) AT=1470.05n

.meas tran vdout0_1ck1460 FIND v(dout0_1) AT=1470.05n

.meas tran vdout0_2ck1460 FIND v(dout0_2) AT=1470.05n

.meas tran vdout0_3ck1460 FIND v(dout0_3) AT=1470.05n

.meas tran vdout0_4ck1460 FIND v(dout0_4) AT=1470.05n

.meas tran vdout0_5ck1460 FIND v(dout0_5) AT=1470.05n

.meas tran vdout0_6ck1460 FIND v(dout0_6) AT=1470.05n

.meas tran vdout0_7ck1460 FIND v(dout0_7) AT=1470.05n

.meas tran vdout0_8ck1460 FIND v(dout0_8) AT=1470.05n

.meas tran vdout0_0ck1470 FIND v(dout0_0) AT=1480.05n

.meas tran vdout0_1ck1470 FIND v(dout0_1) AT=1480.05n

.meas tran vdout0_2ck1470 FIND v(dout0_2) AT=1480.05n

.meas tran vdout0_3ck1470 FIND v(dout0_3) AT=1480.05n

.meas tran vdout0_4ck1470 FIND v(dout0_4) AT=1480.05n

.meas tran vdout0_5ck1470 FIND v(dout0_5) AT=1480.05n

.meas tran vdout0_6ck1470 FIND v(dout0_6) AT=1480.05n

.meas tran vdout0_7ck1470 FIND v(dout0_7) AT=1480.05n

.meas tran vdout0_8ck1470 FIND v(dout0_8) AT=1480.05n

.meas tran vdout0_0ck1480 FIND v(dout0_0) AT=1490.05n

.meas tran vdout0_1ck1480 FIND v(dout0_1) AT=1490.05n

.meas tran vdout0_2ck1480 FIND v(dout0_2) AT=1490.05n

.meas tran vdout0_3ck1480 FIND v(dout0_3) AT=1490.05n

.meas tran vdout0_4ck1480 FIND v(dout0_4) AT=1490.05n

.meas tran vdout0_5ck1480 FIND v(dout0_5) AT=1490.05n

.meas tran vdout0_6ck1480 FIND v(dout0_6) AT=1490.05n

.meas tran vdout0_7ck1480 FIND v(dout0_7) AT=1490.05n

.meas tran vdout0_8ck1480 FIND v(dout0_8) AT=1490.05n

.meas tran vdout0_0ck1490 FIND v(dout0_0) AT=1500.05n

.meas tran vdout0_1ck1490 FIND v(dout0_1) AT=1500.05n

.meas tran vdout0_2ck1490 FIND v(dout0_2) AT=1500.05n

.meas tran vdout0_3ck1490 FIND v(dout0_3) AT=1500.05n

.meas tran vdout0_4ck1490 FIND v(dout0_4) AT=1500.05n

.meas tran vdout0_5ck1490 FIND v(dout0_5) AT=1500.05n

.meas tran vdout0_6ck1490 FIND v(dout0_6) AT=1500.05n

.meas tran vdout0_7ck1490 FIND v(dout0_7) AT=1500.05n

.meas tran vdout0_8ck1490 FIND v(dout0_8) AT=1500.05n

.meas tran vdout0_0ck1520 FIND v(dout0_0) AT=1530.05n

.meas tran vdout0_1ck1520 FIND v(dout0_1) AT=1530.05n

.meas tran vdout0_2ck1520 FIND v(dout0_2) AT=1530.05n

.meas tran vdout0_3ck1520 FIND v(dout0_3) AT=1530.05n

.meas tran vdout0_4ck1520 FIND v(dout0_4) AT=1530.05n

.meas tran vdout0_5ck1520 FIND v(dout0_5) AT=1530.05n

.meas tran vdout0_6ck1520 FIND v(dout0_6) AT=1530.05n

.meas tran vdout0_7ck1520 FIND v(dout0_7) AT=1530.05n

.meas tran vdout0_8ck1520 FIND v(dout0_8) AT=1530.05n

.meas tran vdout0_0ck1540 FIND v(dout0_0) AT=1550.05n

.meas tran vdout0_1ck1540 FIND v(dout0_1) AT=1550.05n

.meas tran vdout0_2ck1540 FIND v(dout0_2) AT=1550.05n

.meas tran vdout0_3ck1540 FIND v(dout0_3) AT=1550.05n

.meas tran vdout0_4ck1540 FIND v(dout0_4) AT=1550.05n

.meas tran vdout0_5ck1540 FIND v(dout0_5) AT=1550.05n

.meas tran vdout0_6ck1540 FIND v(dout0_6) AT=1550.05n

.meas tran vdout0_7ck1540 FIND v(dout0_7) AT=1550.05n

.meas tran vdout0_8ck1540 FIND v(dout0_8) AT=1550.05n

.meas tran vdout0_0ck1550 FIND v(dout0_0) AT=1560.05n

.meas tran vdout0_1ck1550 FIND v(dout0_1) AT=1560.05n

.meas tran vdout0_2ck1550 FIND v(dout0_2) AT=1560.05n

.meas tran vdout0_3ck1550 FIND v(dout0_3) AT=1560.05n

.meas tran vdout0_4ck1550 FIND v(dout0_4) AT=1560.05n

.meas tran vdout0_5ck1550 FIND v(dout0_5) AT=1560.05n

.meas tran vdout0_6ck1550 FIND v(dout0_6) AT=1560.05n

.meas tran vdout0_7ck1550 FIND v(dout0_7) AT=1560.05n

.meas tran vdout0_8ck1550 FIND v(dout0_8) AT=1560.05n

.meas tran vdout0_0ck1570 FIND v(dout0_0) AT=1580.05n

.meas tran vdout0_1ck1570 FIND v(dout0_1) AT=1580.05n

.meas tran vdout0_2ck1570 FIND v(dout0_2) AT=1580.05n

.meas tran vdout0_3ck1570 FIND v(dout0_3) AT=1580.05n

.meas tran vdout0_4ck1570 FIND v(dout0_4) AT=1580.05n

.meas tran vdout0_5ck1570 FIND v(dout0_5) AT=1580.05n

.meas tran vdout0_6ck1570 FIND v(dout0_6) AT=1580.05n

.meas tran vdout0_7ck1570 FIND v(dout0_7) AT=1580.05n

.meas tran vdout0_8ck1570 FIND v(dout0_8) AT=1580.05n

.meas tran vdout0_0ck1590 FIND v(dout0_0) AT=1600.05n

.meas tran vdout0_1ck1590 FIND v(dout0_1) AT=1600.05n

.meas tran vdout0_2ck1590 FIND v(dout0_2) AT=1600.05n

.meas tran vdout0_3ck1590 FIND v(dout0_3) AT=1600.05n

.meas tran vdout0_4ck1590 FIND v(dout0_4) AT=1600.05n

.meas tran vdout0_5ck1590 FIND v(dout0_5) AT=1600.05n

.meas tran vdout0_6ck1590 FIND v(dout0_6) AT=1600.05n

.meas tran vdout0_7ck1590 FIND v(dout0_7) AT=1600.05n

.meas tran vdout0_8ck1590 FIND v(dout0_8) AT=1600.05n

.meas tran vdout0_0ck1600 FIND v(dout0_0) AT=1610.05n

.meas tran vdout0_1ck1600 FIND v(dout0_1) AT=1610.05n

.meas tran vdout0_2ck1600 FIND v(dout0_2) AT=1610.05n

.meas tran vdout0_3ck1600 FIND v(dout0_3) AT=1610.05n

.meas tran vdout0_4ck1600 FIND v(dout0_4) AT=1610.05n

.meas tran vdout0_5ck1600 FIND v(dout0_5) AT=1610.05n

.meas tran vdout0_6ck1600 FIND v(dout0_6) AT=1610.05n

.meas tran vdout0_7ck1600 FIND v(dout0_7) AT=1610.05n

.meas tran vdout0_8ck1600 FIND v(dout0_8) AT=1610.05n

.meas tran vdout0_0ck1630 FIND v(dout0_0) AT=1640.05n

.meas tran vdout0_1ck1630 FIND v(dout0_1) AT=1640.05n

.meas tran vdout0_2ck1630 FIND v(dout0_2) AT=1640.05n

.meas tran vdout0_3ck1630 FIND v(dout0_3) AT=1640.05n

.meas tran vdout0_4ck1630 FIND v(dout0_4) AT=1640.05n

.meas tran vdout0_5ck1630 FIND v(dout0_5) AT=1640.05n

.meas tran vdout0_6ck1630 FIND v(dout0_6) AT=1640.05n

.meas tran vdout0_7ck1630 FIND v(dout0_7) AT=1640.05n

.meas tran vdout0_8ck1630 FIND v(dout0_8) AT=1640.05n

.meas tran vdout0_0ck1640 FIND v(dout0_0) AT=1650.05n

.meas tran vdout0_1ck1640 FIND v(dout0_1) AT=1650.05n

.meas tran vdout0_2ck1640 FIND v(dout0_2) AT=1650.05n

.meas tran vdout0_3ck1640 FIND v(dout0_3) AT=1650.05n

.meas tran vdout0_4ck1640 FIND v(dout0_4) AT=1650.05n

.meas tran vdout0_5ck1640 FIND v(dout0_5) AT=1650.05n

.meas tran vdout0_6ck1640 FIND v(dout0_6) AT=1650.05n

.meas tran vdout0_7ck1640 FIND v(dout0_7) AT=1650.05n

.meas tran vdout0_8ck1640 FIND v(dout0_8) AT=1650.05n

.meas tran vdout0_0ck1650 FIND v(dout0_0) AT=1660.05n

.meas tran vdout0_1ck1650 FIND v(dout0_1) AT=1660.05n

.meas tran vdout0_2ck1650 FIND v(dout0_2) AT=1660.05n

.meas tran vdout0_3ck1650 FIND v(dout0_3) AT=1660.05n

.meas tran vdout0_4ck1650 FIND v(dout0_4) AT=1660.05n

.meas tran vdout0_5ck1650 FIND v(dout0_5) AT=1660.05n

.meas tran vdout0_6ck1650 FIND v(dout0_6) AT=1660.05n

.meas tran vdout0_7ck1650 FIND v(dout0_7) AT=1660.05n

.meas tran vdout0_8ck1650 FIND v(dout0_8) AT=1660.05n

.meas tran vdout0_0ck1700 FIND v(dout0_0) AT=1710.05n

.meas tran vdout0_1ck1700 FIND v(dout0_1) AT=1710.05n

.meas tran vdout0_2ck1700 FIND v(dout0_2) AT=1710.05n

.meas tran vdout0_3ck1700 FIND v(dout0_3) AT=1710.05n

.meas tran vdout0_4ck1700 FIND v(dout0_4) AT=1710.05n

.meas tran vdout0_5ck1700 FIND v(dout0_5) AT=1710.05n

.meas tran vdout0_6ck1700 FIND v(dout0_6) AT=1710.05n

.meas tran vdout0_7ck1700 FIND v(dout0_7) AT=1710.05n

.meas tran vdout0_8ck1700 FIND v(dout0_8) AT=1710.05n

.meas tran vdout0_0ck1730 FIND v(dout0_0) AT=1740.05n

.meas tran vdout0_1ck1730 FIND v(dout0_1) AT=1740.05n

.meas tran vdout0_2ck1730 FIND v(dout0_2) AT=1740.05n

.meas tran vdout0_3ck1730 FIND v(dout0_3) AT=1740.05n

.meas tran vdout0_4ck1730 FIND v(dout0_4) AT=1740.05n

.meas tran vdout0_5ck1730 FIND v(dout0_5) AT=1740.05n

.meas tran vdout0_6ck1730 FIND v(dout0_6) AT=1740.05n

.meas tran vdout0_7ck1730 FIND v(dout0_7) AT=1740.05n

.meas tran vdout0_8ck1730 FIND v(dout0_8) AT=1740.05n

.meas tran vdout0_0ck1740 FIND v(dout0_0) AT=1750.05n

.meas tran vdout0_1ck1740 FIND v(dout0_1) AT=1750.05n

.meas tran vdout0_2ck1740 FIND v(dout0_2) AT=1750.05n

.meas tran vdout0_3ck1740 FIND v(dout0_3) AT=1750.05n

.meas tran vdout0_4ck1740 FIND v(dout0_4) AT=1750.05n

.meas tran vdout0_5ck1740 FIND v(dout0_5) AT=1750.05n

.meas tran vdout0_6ck1740 FIND v(dout0_6) AT=1750.05n

.meas tran vdout0_7ck1740 FIND v(dout0_7) AT=1750.05n

.meas tran vdout0_8ck1740 FIND v(dout0_8) AT=1750.05n

.meas tran vdout0_0ck1760 FIND v(dout0_0) AT=1770.05n

.meas tran vdout0_1ck1760 FIND v(dout0_1) AT=1770.05n

.meas tran vdout0_2ck1760 FIND v(dout0_2) AT=1770.05n

.meas tran vdout0_3ck1760 FIND v(dout0_3) AT=1770.05n

.meas tran vdout0_4ck1760 FIND v(dout0_4) AT=1770.05n

.meas tran vdout0_5ck1760 FIND v(dout0_5) AT=1770.05n

.meas tran vdout0_6ck1760 FIND v(dout0_6) AT=1770.05n

.meas tran vdout0_7ck1760 FIND v(dout0_7) AT=1770.05n

.meas tran vdout0_8ck1760 FIND v(dout0_8) AT=1770.05n

.meas tran vdout0_0ck1800 FIND v(dout0_0) AT=1810.05n

.meas tran vdout0_1ck1800 FIND v(dout0_1) AT=1810.05n

.meas tran vdout0_2ck1800 FIND v(dout0_2) AT=1810.05n

.meas tran vdout0_3ck1800 FIND v(dout0_3) AT=1810.05n

.meas tran vdout0_4ck1800 FIND v(dout0_4) AT=1810.05n

.meas tran vdout0_5ck1800 FIND v(dout0_5) AT=1810.05n

.meas tran vdout0_6ck1800 FIND v(dout0_6) AT=1810.05n

.meas tran vdout0_7ck1800 FIND v(dout0_7) AT=1810.05n

.meas tran vdout0_8ck1800 FIND v(dout0_8) AT=1810.05n

.meas tran vdout0_0ck1810 FIND v(dout0_0) AT=1820.05n

.meas tran vdout0_1ck1810 FIND v(dout0_1) AT=1820.05n

.meas tran vdout0_2ck1810 FIND v(dout0_2) AT=1820.05n

.meas tran vdout0_3ck1810 FIND v(dout0_3) AT=1820.05n

.meas tran vdout0_4ck1810 FIND v(dout0_4) AT=1820.05n

.meas tran vdout0_5ck1810 FIND v(dout0_5) AT=1820.05n

.meas tran vdout0_6ck1810 FIND v(dout0_6) AT=1820.05n

.meas tran vdout0_7ck1810 FIND v(dout0_7) AT=1820.05n

.meas tran vdout0_8ck1810 FIND v(dout0_8) AT=1820.05n

.meas tran vdout0_0ck1830 FIND v(dout0_0) AT=1840.05n

.meas tran vdout0_1ck1830 FIND v(dout0_1) AT=1840.05n

.meas tran vdout0_2ck1830 FIND v(dout0_2) AT=1840.05n

.meas tran vdout0_3ck1830 FIND v(dout0_3) AT=1840.05n

.meas tran vdout0_4ck1830 FIND v(dout0_4) AT=1840.05n

.meas tran vdout0_5ck1830 FIND v(dout0_5) AT=1840.05n

.meas tran vdout0_6ck1830 FIND v(dout0_6) AT=1840.05n

.meas tran vdout0_7ck1830 FIND v(dout0_7) AT=1840.05n

.meas tran vdout0_8ck1830 FIND v(dout0_8) AT=1840.05n

.meas tran vdout0_0ck1850 FIND v(dout0_0) AT=1860.05n

.meas tran vdout0_1ck1850 FIND v(dout0_1) AT=1860.05n

.meas tran vdout0_2ck1850 FIND v(dout0_2) AT=1860.05n

.meas tran vdout0_3ck1850 FIND v(dout0_3) AT=1860.05n

.meas tran vdout0_4ck1850 FIND v(dout0_4) AT=1860.05n

.meas tran vdout0_5ck1850 FIND v(dout0_5) AT=1860.05n

.meas tran vdout0_6ck1850 FIND v(dout0_6) AT=1860.05n

.meas tran vdout0_7ck1850 FIND v(dout0_7) AT=1860.05n

.meas tran vdout0_8ck1850 FIND v(dout0_8) AT=1860.05n

.meas tran vdout0_0ck1870 FIND v(dout0_0) AT=1880.05n

.meas tran vdout0_1ck1870 FIND v(dout0_1) AT=1880.05n

.meas tran vdout0_2ck1870 FIND v(dout0_2) AT=1880.05n

.meas tran vdout0_3ck1870 FIND v(dout0_3) AT=1880.05n

.meas tran vdout0_4ck1870 FIND v(dout0_4) AT=1880.05n

.meas tran vdout0_5ck1870 FIND v(dout0_5) AT=1880.05n

.meas tran vdout0_6ck1870 FIND v(dout0_6) AT=1880.05n

.meas tran vdout0_7ck1870 FIND v(dout0_7) AT=1880.05n

.meas tran vdout0_8ck1870 FIND v(dout0_8) AT=1880.05n

.meas tran vdout0_0ck1880 FIND v(dout0_0) AT=1890.05n

.meas tran vdout0_1ck1880 FIND v(dout0_1) AT=1890.05n

.meas tran vdout0_2ck1880 FIND v(dout0_2) AT=1890.05n

.meas tran vdout0_3ck1880 FIND v(dout0_3) AT=1890.05n

.meas tran vdout0_4ck1880 FIND v(dout0_4) AT=1890.05n

.meas tran vdout0_5ck1880 FIND v(dout0_5) AT=1890.05n

.meas tran vdout0_6ck1880 FIND v(dout0_6) AT=1890.05n

.meas tran vdout0_7ck1880 FIND v(dout0_7) AT=1890.05n

.meas tran vdout0_8ck1880 FIND v(dout0_8) AT=1890.05n

.meas tran vdout0_0ck1900 FIND v(dout0_0) AT=1910.05n

.meas tran vdout0_1ck1900 FIND v(dout0_1) AT=1910.05n

.meas tran vdout0_2ck1900 FIND v(dout0_2) AT=1910.05n

.meas tran vdout0_3ck1900 FIND v(dout0_3) AT=1910.05n

.meas tran vdout0_4ck1900 FIND v(dout0_4) AT=1910.05n

.meas tran vdout0_5ck1900 FIND v(dout0_5) AT=1910.05n

.meas tran vdout0_6ck1900 FIND v(dout0_6) AT=1910.05n

.meas tran vdout0_7ck1900 FIND v(dout0_7) AT=1910.05n

.meas tran vdout0_8ck1900 FIND v(dout0_8) AT=1910.05n

.meas tran vdout0_0ck1910 FIND v(dout0_0) AT=1920.05n

.meas tran vdout0_1ck1910 FIND v(dout0_1) AT=1920.05n

.meas tran vdout0_2ck1910 FIND v(dout0_2) AT=1920.05n

.meas tran vdout0_3ck1910 FIND v(dout0_3) AT=1920.05n

.meas tran vdout0_4ck1910 FIND v(dout0_4) AT=1920.05n

.meas tran vdout0_5ck1910 FIND v(dout0_5) AT=1920.05n

.meas tran vdout0_6ck1910 FIND v(dout0_6) AT=1920.05n

.meas tran vdout0_7ck1910 FIND v(dout0_7) AT=1920.05n

.meas tran vdout0_8ck1910 FIND v(dout0_8) AT=1920.05n

.meas tran vdout0_0ck1920 FIND v(dout0_0) AT=1930.05n

.meas tran vdout0_1ck1920 FIND v(dout0_1) AT=1930.05n

.meas tran vdout0_2ck1920 FIND v(dout0_2) AT=1930.05n

.meas tran vdout0_3ck1920 FIND v(dout0_3) AT=1930.05n

.meas tran vdout0_4ck1920 FIND v(dout0_4) AT=1930.05n

.meas tran vdout0_5ck1920 FIND v(dout0_5) AT=1930.05n

.meas tran vdout0_6ck1920 FIND v(dout0_6) AT=1930.05n

.meas tran vdout0_7ck1920 FIND v(dout0_7) AT=1930.05n

.meas tran vdout0_8ck1920 FIND v(dout0_8) AT=1930.05n

.meas tran vdout0_0ck1970 FIND v(dout0_0) AT=1980.05n

.meas tran vdout0_1ck1970 FIND v(dout0_1) AT=1980.05n

.meas tran vdout0_2ck1970 FIND v(dout0_2) AT=1980.05n

.meas tran vdout0_3ck1970 FIND v(dout0_3) AT=1980.05n

.meas tran vdout0_4ck1970 FIND v(dout0_4) AT=1980.05n

.meas tran vdout0_5ck1970 FIND v(dout0_5) AT=1980.05n

.meas tran vdout0_6ck1970 FIND v(dout0_6) AT=1980.05n

.meas tran vdout0_7ck1970 FIND v(dout0_7) AT=1980.05n

.meas tran vdout0_8ck1970 FIND v(dout0_8) AT=1980.05n

.meas tran vdout0_0ck1990 FIND v(dout0_0) AT=2000.05n

.meas tran vdout0_1ck1990 FIND v(dout0_1) AT=2000.05n

.meas tran vdout0_2ck1990 FIND v(dout0_2) AT=2000.05n

.meas tran vdout0_3ck1990 FIND v(dout0_3) AT=2000.05n

.meas tran vdout0_4ck1990 FIND v(dout0_4) AT=2000.05n

.meas tran vdout0_5ck1990 FIND v(dout0_5) AT=2000.05n

.meas tran vdout0_6ck1990 FIND v(dout0_6) AT=2000.05n

.meas tran vdout0_7ck1990 FIND v(dout0_7) AT=2000.05n

.meas tran vdout0_8ck1990 FIND v(dout0_8) AT=2000.05n

.meas tran vdout0_0ck2010 FIND v(dout0_0) AT=2020.05n

.meas tran vdout0_1ck2010 FIND v(dout0_1) AT=2020.05n

.meas tran vdout0_2ck2010 FIND v(dout0_2) AT=2020.05n

.meas tran vdout0_3ck2010 FIND v(dout0_3) AT=2020.05n

.meas tran vdout0_4ck2010 FIND v(dout0_4) AT=2020.05n

.meas tran vdout0_5ck2010 FIND v(dout0_5) AT=2020.05n

.meas tran vdout0_6ck2010 FIND v(dout0_6) AT=2020.05n

.meas tran vdout0_7ck2010 FIND v(dout0_7) AT=2020.05n

.meas tran vdout0_8ck2010 FIND v(dout0_8) AT=2020.05n

.meas tran vdout0_0ck2030 FIND v(dout0_0) AT=2040.05n

.meas tran vdout0_1ck2030 FIND v(dout0_1) AT=2040.05n

.meas tran vdout0_2ck2030 FIND v(dout0_2) AT=2040.05n

.meas tran vdout0_3ck2030 FIND v(dout0_3) AT=2040.05n

.meas tran vdout0_4ck2030 FIND v(dout0_4) AT=2040.05n

.meas tran vdout0_5ck2030 FIND v(dout0_5) AT=2040.05n

.meas tran vdout0_6ck2030 FIND v(dout0_6) AT=2040.05n

.meas tran vdout0_7ck2030 FIND v(dout0_7) AT=2040.05n

.meas tran vdout0_8ck2030 FIND v(dout0_8) AT=2040.05n

.meas tran vdout0_0ck2040 FIND v(dout0_0) AT=2050.05n

.meas tran vdout0_1ck2040 FIND v(dout0_1) AT=2050.05n

.meas tran vdout0_2ck2040 FIND v(dout0_2) AT=2050.05n

.meas tran vdout0_3ck2040 FIND v(dout0_3) AT=2050.05n

.meas tran vdout0_4ck2040 FIND v(dout0_4) AT=2050.05n

.meas tran vdout0_5ck2040 FIND v(dout0_5) AT=2050.05n

.meas tran vdout0_6ck2040 FIND v(dout0_6) AT=2050.05n

.meas tran vdout0_7ck2040 FIND v(dout0_7) AT=2050.05n

.meas tran vdout0_8ck2040 FIND v(dout0_8) AT=2050.05n
